* Post-layout EXTRACTED DUT netlist -- GENERATED, do not edit by hand.
*
* extract report : layout/lvs/reports/gate_driver_core/20261114-194101-cbf0cd4.extract.json
* layout gds     : {'path': 'layout/gate_driver_core.gds', 'scope': 'repo'}
* extraction deck: gf180mcu (sha256:c3f2cce49000857a3a71cb65203aabf0eb27cd0ee6b1c60e29792355c455c4b1)  (klt extract)
* klt/klayout    : 0.9.2.dev1029+g76f47afa48f1 / 0.30.13
* devices        : 2044 {'cap_mim_2f0_m4m5_noshield': 4, 'nfet': 1105, 'pfet': 664, 'ppolyf_u': 271} -> {'nfet_03v3': 3, 'nfet_06v0': 1102, 'pfet_03v3': 1, 'pfet_06v0': 663, 'cap_mim_2f0_m4m5_noshield': 4, 'ppolyf_u': 271}
* regenerate     : python3 layout/lvs/mk_extracted_dut.py --extract layout/lvs/reports/gate_driver_core/20261114-194101-cbf0cd4.extract.json --combine -o layout/lvs/gate_driver_core.extracted.spice
*
* ------------------------------------------------------------------
* Mechanical transforms applied to the extractor's own output
* ------------------------------------------------------------------
* T1. Flattening: the extractor's `.SUBCKT gate_driver_core ... .ENDS` wrapper
*     is dropped -- every device/parasitic card is emitted at deck level,
*     matching this repo's existing DUT-fragment convention
*     (design/netlist/gate_driver_core.spice's own top .subckt line is commented
*     out for the identical reason -- design/README.md).
* T2. MOS cards: the extractor's `M<n> d g s b nfet|pfet L=..U W=..U` is rebound
*     to the real gf180mcu `nfet_03v3`/`nfet_06v0`/`pfet_03v3`/`pfet_06v0`
*     subcircuit, selected by (device class, drawn L) -- the extraction deck's
*     generic `nfet`/`pfet` device class does not distinguish voltage flavor
*     (gate_driver_core.checks.json's voltage_domain_warnings; also
*     layout/lvs/make_reference.py's transform 2), but this design's drawn L
*     cleanly disjoint-identifies it. `nf=1 m=1`: each extracted device is one
*     drawn finger, so the schematic's `nf`/`m` multipliers are already spent as
*     real, separately-extracted geometry. Emitted as an `X<n>` subcircuit call,
*     matching design/netlist/gate_driver_core.spice's own device cards, because
*     those PDK models ARE .subckts: ngspice will resolve an `M` card against a
*     subcircuit of that name, but then expands `m=<n>` into n separate
*     subcircuit instances instead of passing m down to the model -- measured at
*     3.32 s of CPU for the `X` form of this netlist versus ~2200 s for the `M`
*     form, at bit-identical measured results.
* T3. MOS junction geometry: AS/AD/PS/PD are carried through verbatim from the
*     extractor's own measured `as_um2`/`ad_um2`/`ps_um`/`pd_um` (unlike
*     gf180-bandgap's deck, this deck's gf180mcu extractor reports these
*     directly -- no recomputation needed).
* T4. MOS body terminal: rebound to the real rail this design's schematic ties
*     that flavor to -- GND_LOGIC/GND_DRV for NMOS, VDD_LOGIC/VDD_DRV for PMOS,
*     selected by the same (class, L) binning as T2. Issue #132 drew real
*     per-device body-tie geometry for every device (both flavors), and a real
*     `klt extract` of that geometry now measures exactly this assignment on its
*     own (PMOS: each device's own real Nwell-tie net; NMOS: the deck's global
*     substrate identity, which is itself now wired to real labeled
*     GND_LOGIC/GND_DRV metal instead of floating -- klayout-tools #1128,
*     layout/lvs/make_reference.py's transform 3/5) -- so this transform is now
*     a redundant assertion of an already-measured fact, not a fabrication
*     filling a gap the deck cannot see. It stays a rebind (rather than reading
*     `dev['nets']['b']` directly) so GND_LOGIC and GND_DRV keep their own
*     separate names here -- the deck's own raw extraction merges both grounds
*     into one synthesized joined label (`GND_DRV|GND_LOGIC`) it has no
*     equivalent synthesized label for on the supply side, and T5's per-net
*     parasitic stars are keyed by the schematic's own real net names, not that
*     merged one. See BA1/BA2 and layout/README.md.
* T5. Parasitics (only when `klt extract --parasitics` was used): each named
*     net's own per-terminal star (device leg -> resistor -> hub) and hub ->
*     capacitor -> ground-reference are carried through verbatim from
*     `parasitics.nets[]`, renaming only the ground reference itself (`vsubs` ->
*     GND_LOGIC, T4/BA3, since the deck reports no parasitics entry for `vsubs`
*     as a net in its own right). Net-to-net coupling capacitance
*     (`parasitics.nets[].coupled`) is NOT emitted -- a documented scope
*     reduction, not a silent drop; every ground-referenced term is measured,
*     every coupling term is omitted, stated once here rather than per-record.
*     Since issue #132 the extraction deck reports BOTH ground rails as one
*     merged net (klayout-tools #1128), which has no single hub of its own here:
*     every terminal on it belongs to exactly one real ground domain by (class,
*     L) (T4/BA1), so each of its legs is emitted with the leg's OWN device's
*     real GND_LOGIC/GND_DRV as that leg's hub -- the same per-device rebind the
*     leg net itself gets, never one shared hub (which would reroute one
*     domain's return current through the testbench's inter-rail tie; see
*     MERGED_GROUND_RAW). That reproduces exactly the pre-#132 topology, where
*     each rail's own star hub WAS that rail's node: 297 ground-rail R legs
*     (issue #184). The merged net's own measured ground capacitance is emitted
*     once between the two real rails it spans (GND_DRV<->GND_LOGIC), the same
*     place the pre-#132 GND_DRV star's cap landed -- the deck reports one
*     lumped value for the merged metal and resolves no per-domain split, so it
*     is carried whole rather than apportioned by assertion.
* T6. (only with --combine, and only on a non-parasitic extraction) Device
*     folding: parallel-identical fingers of one schematic device (exactly
*     matching (model, d, g, s, body, L, W, AD, AS, PD, PS) after T2/T4) are
*     folded back into one `m=<n>` card. This is a simulation- cost
*     optimization, not a fidelity change -- an ideal parallel combination of n
*     identical devices *is* `m=n` in SPICE -- needed because 959
*     individually-instantiated fingers (one per drawn finger, this script's
*     default) cost roughly three orders of magnitude more simulation time than
*     the same circuit as `m=`-scaled instances, to the point of being
*     PVT-grid-infeasible within a bounded evidence run.
* T7. (issue #166/#201) Passive cards: a CAP_CLASSES device (this design's only
*     case: the four-deep XCCOMP MiM series stack) has no d/g/s/b terminals and
*     no gf180mcu subcircuit to rebind to -- it is emitted directly as an
*     ngspice `C<n> a b <value>` card, `value` carried through verbatim from the
*     extractor's own measured `params.c_f` (the same two-term area+perimeter
*     model make_reference.py's transform 6 restates over the schematic
*     geometry). Never grouped by --combine: with only four instances there is
*     no simulation-cost case for folding them, and each occupies a distinct
*     position in the series chain (distinct nets), so no two are ever
*     combine-eligible anyway. Its two terminals still route through T5's
*     per-net leg resistor the same as any MOS terminal when --parasitics is
*     present -- the merged-ground body-terminal skip below is scoped to MOS
*     devices only so it cannot mistake a capacitor's `b` terminal for a MOS
*     body leg.
* T8. (issue #201) Anonymous-net rename: any net the extractor names `$N` (its
*     own convention for a net with no schematic label -- this design's first
*     real case is T7's XCCOMP inter-cap nodes) is rewritten to `ANON<N>`
*     wherever it would otherwise appear as a bare SPICE node token. `$`
*     starting a token is an inline-comment marker to ngspice, so left as-is
*     these nets silently truncate every card that names them -- no simulator
*     error, just a per-card `... is not a valid ... line, ignored!` warning
*     outside this script's or run_corners.py's own PASS/FAIL summary. Applied
*     at every point a raw extractor net name reaches a bare node position
*     (`leg_of()`'s return, and T5's per-net star loop); never applied to a name
*     only ever embedded inside a longer instance name (e.g. an R-leg card's own
*     `R$18__t0` name field), since a `$` that is not a token's first character
*     does not trigger this.
* T9. (issue #221/#222) Passive cards: a RES_CLASSES device (this design's only
*     case: uvlo's Rref/R1/R2/Rfb bias-resistor network, drawn as a chain of
*     `ppolyf_u` unit resistors) has no d/g/s/b terminals and no gf180mcu
*     subcircuit to rebind to -- it is emitted directly as an ngspice `R<n> a b
*     <value>` card, `value` carried through verbatim from the extractor's own
*     measured `params.r_ohm`. Its `a`/`b` terminals still route through T5's
*     per-net leg resistor the same as any MOS or CAP_CLASSES terminal when
*     --parasitics is present. Its third terminal (`w`, the device's own
*     guard/tap net) is NOT referenced by the emitted `R` card at all -- see BA4
*     -- so it is never looked up via leg_of() for this device. Unlike
*     --combine's MOS finger folding, no attempt is made to fold a schematic
*     resistor's own drawn chain of unit resistors back into one series value:
*     ngspice sums a chain of series `R` cards exactly, at no extra simulation
*     cost (unlike a MOS `M`-vs-`X`-card finger count, chaining resistor cards
*     is not a solver-cost concern), so every unit resistor is emitted
*     individually regardless of --combine.
*
* ------------------------------------------------------------------
* Back-annotated: terminals/nets the extraction deck cannot resolve
* ------------------------------------------------------------------
* BA1  NMOS body -> GND_LOGIC (3.3V flavor) / GND_DRV (6V flavor)
*      (issue #132: real substrate-tie geometry now measures this same
*       assignment directly -- klt lvs reports zero device.body_unverified
*       mismatches for either flavor. Kept as a rebind, not a fabrication,
*       so GND_LOGIC/GND_DRV keep separate names here -- see T4)
* BA2  PMOS body -> VDD_LOGIC (3.3V flavor) / VDD_DRV (6V flavor)
*      (issue #132: real well-tie geometry now measures this same
*       assignment directly, per device -- redundant with T4, not a gap)
* BA3  parasitic ground-cap reference `vsubs` -> GND_LOGIC
*      (GND_LOGIC/GND_DRV are one electrical node by design intent;
*       GND_LOGIC is the documented, arbitrary choice of the two. `vsubs`
*       itself no longer appears in a real extraction of this layout --
*       see make_reference.py transform 3 -- but a --parasitics run's
*       own per-net table is still keyed by the schematic's pre-merge
*       net names, so this rename is still the correct lookup key)
* BA4  RES_CLASSES device's `w` (guard/tap) terminal -> not modeled
*      (gf180mcu's ppolyf_u resistor model exposes a third terminal for
*       the device's own guard-ring/substrate tap; the plain two-terminal
*       `R` card T9 emits has no node for it. This is a documented scope
*       reduction, not a silent drop: the schematic's own bare `R` cards
*       (design/netlist/uvlo.spice) never modeled a guard-tap terminal
*       either, so nothing measurable at the schematic level is lost)
*
* sha256 (this file, sans this line): 34fc06b2ef8eeab06e76ee3ce6200cf5
* Everything else -- device existence, drawn W/L/AS/AD/PS/PD,
* drain/gate/source connectivity, and (when present) the per-net
* ground-referenced RC parasitics -- is measured, not asserted.

* FLAT form: device/parasitic cards at deck level, no `.SUBCKT` wrapper --
* matches this repo's existing DUT-fragment convention (T1).

X1 x1_inb IN GND_LOGIC GND_LOGIC nfet_03v3 L=0.28U W=5U nf=1 ad=2.5P as=2.5P pd=11U ps=11U m=1
X2 x1_na IN GND_LOGIC GND_LOGIC nfet_03v3 L=0.28U W=20U nf=1 ad=10P as=10P pd=41U ps=41U m=1
X3 x1_nb x1_inb GND_LOGIC GND_LOGIC nfet_03v3 L=0.28U W=20U nf=1 ad=10P as=10P pd=41U ps=41U m=1
X4 GND_DRV x2_n3 x2_n4 GND_DRV nfet_06v0 L=0.7U W=10U nf=1 ad=2.9P as=2.9P pd=10.58U ps=10.58U m=6
X5 GND_DRV x2_n3 x2_n4 GND_DRV nfet_06v0 L=0.7U W=10U nf=1 ad=5P as=2.9P pd=21U ps=10.58U m=1
X6 GND_DRV x2_n4 x2_n5 GND_DRV nfet_06v0 L=0.7U W=10U nf=1 ad=2.9P as=2.9P pd=10.58U ps=10.58U m=27
X7 GND_DRV x2_n5 OUT GND_DRV nfet_06v0 L=0.7U W=10U nf=1 ad=2.9P as=2.9P pd=10.58U ps=10.58U m=109
X8 GND_DRV x2_n5 OUT GND_DRV nfet_06v0 L=0.7U W=10U nf=1 ad=5P as=2.9P pd=21U ps=10.58U m=1
X9 GND_DRV x3_lockout OUT GND_DRV nfet_06v0 L=0.7U W=10U nf=1 ad=2.9P as=2.9P pd=10.58U ps=10.58U m=399
X10 GND_DRV x3_lockout OUT GND_DRV nfet_06v0 L=0.7U W=10U nf=1 ad=5P as=2.9P pd=21U ps=10.58U m=1
X11 IN_DRV x1_nbuf1 GND_DRV GND_DRV nfet_06v0 L=0.7U W=15U nf=1 ad=7.5P as=7.5P pd=31U ps=31U m=1
X12 OUT x2_n5 GND_DRV GND_DRV nfet_06v0 L=0.7U W=10U nf=1 ad=2.9P as=2.9P pd=10.58U ps=10.58U m=109
X13 OUT x2_n5 GND_DRV GND_DRV nfet_06v0 L=0.7U W=10U nf=1 ad=2.9P as=5P pd=10.58U ps=21U m=1
X14 OUT x3_lockout GND_DRV GND_DRV nfet_06v0 L=0.7U W=10U nf=1 ad=2.9P as=2.9P pd=10.58U ps=10.58U m=399
X15 OUT x3_lockout GND_DRV GND_DRV nfet_06v0 L=0.7U W=10U nf=1 ad=2.9P as=5P pd=10.58U ps=21U m=1
X16 x1_nbuf1 x1_ncb GND_DRV GND_DRV nfet_06v0 L=0.7U W=5U nf=1 ad=2.5P as=2.5P pd=11U ps=11U m=1
X17 x1_nca VDD_LOGIC x1_na GND_DRV nfet_06v0 L=0.7U W=20U nf=1 ad=10P as=10P pd=41U ps=41U m=1
X18 x1_ncb VDD_LOGIC x1_nb GND_DRV nfet_06v0 L=0.7U W=20U nf=1 ad=10P as=10P pd=41U ps=41U m=1
X19 x2_n1 IN_DRV GND_DRV GND_DRV nfet_06v0 L=0.7U W=2U nf=1 ad=1P as=1P pd=5U ps=5U m=1
X20 x2_n2 x2_n1 GND_DRV GND_DRV nfet_06v0 L=0.7U W=8U nf=1 ad=4P as=4P pd=17U ps=17U m=1
X21 x2_n3 x2_n2 GND_DRV GND_DRV nfet_06v0 L=0.7U W=33U nf=1 ad=16.5P as=16.5P pd=67U ps=67U m=1
X22 x2_n4 x2_n3 GND_DRV GND_DRV nfet_06v0 L=0.7U W=10U nf=1 ad=2.9P as=2.9P pd=10.58U ps=10.58U m=6
X23 x2_n4 x2_n3 GND_DRV GND_DRV nfet_06v0 L=0.7U W=10U nf=1 ad=2.9P as=5P pd=10.58U ps=21U m=1
X24 x2_n5 x2_n4 GND_DRV GND_DRV nfet_06v0 L=0.7U W=10U nf=1 ad=2.9P as=2.9P pd=10.58U ps=10.58U m=26
X25 x2_n5 x2_n4 GND_DRV GND_DRV nfet_06v0 L=0.7U W=10U nf=1 ad=2.9P as=5P pd=10.58U ps=21U m=1
X26 x2_n5 x2_n4 GND_DRV GND_DRV nfet_06v0 L=0.7U W=10U nf=1 ad=5P as=2.9P pd=21U ps=10.58U m=1
X27 x3_lockout x3_ncompn GND_DRV GND_DRV nfet_06v0 L=0.7U W=5U nf=1 ad=2.5P as=2.5P pd=11U ps=11U m=1
X28 x3_ncompn x3_nref x3_ntail GND_DRV nfet_06v0 L=0.7U W=15U nf=1 ad=7.5P as=7.5P pd=31U ps=31U m=1
X29 x3_ncompp x3_ndiv x3_ntail GND_DRV nfet_06v0 L=0.7U W=15U nf=1 ad=7.5P as=7.5P pd=31U ps=31U m=1
X30 x3_nref x3_nref GND_DRV GND_DRV nfet_06v0 L=0.7U W=10U nf=1 ad=5P as=5P pd=21U ps=21U m=1
X31 x3_ntail x3_nref GND_DRV GND_DRV nfet_06v0 L=0.7U W=20U nf=1 ad=10P as=10P pd=41U ps=41U m=1
X32 x3_uvlo_ok x3_lockout GND_DRV GND_DRV nfet_06v0 L=0.7U W=10U nf=1 ad=5P as=5P pd=21U ps=21U m=1
X33 x1_inb IN VDD_LOGIC VDD_LOGIC pfet_03v3 L=0.28U W=10U nf=1 ad=5P as=5P pd=21U ps=21U m=1
X34 IN_DRV x1_nbuf1 VDD_DRV VDD_DRV pfet_06v0 L=0.55U W=15U nf=1 ad=7.5P as=7.5P pd=31U ps=31U m=1
X35 OUT x2_n5 VDD_DRV VDD_DRV pfet_06v0 L=0.55U W=10U nf=1 ad=2.9P as=2.9P pd=10.58U ps=10.58U m=249
X36 OUT x2_n5 VDD_DRV VDD_DRV pfet_06v0 L=0.55U W=10U nf=1 ad=2.9P as=5P pd=10.58U ps=21U m=1
X37 VDD_DRV x2_n3 x2_n4 VDD_DRV pfet_06v0 L=0.55U W=10U nf=1 ad=2.9P as=2.9P pd=10.58U ps=10.58U m=14
X38 VDD_DRV x2_n3 x2_n4 VDD_DRV pfet_06v0 L=0.55U W=10U nf=1 ad=5P as=2.9P pd=21U ps=10.58U m=1
X39 VDD_DRV x2_n4 x2_n5 VDD_DRV pfet_06v0 L=0.55U W=10U nf=1 ad=2.9P as=2.9P pd=10.58U ps=10.58U m=60
X40 VDD_DRV x2_n4 x2_n5 VDD_DRV pfet_06v0 L=0.55U W=10U nf=1 ad=5P as=2.9P pd=21U ps=10.58U m=1
X41 VDD_DRV x2_n5 OUT VDD_DRV pfet_06v0 L=0.55U W=10U nf=1 ad=2.9P as=2.9P pd=10.58U ps=10.58U m=249
X42 VDD_DRV x2_n5 OUT VDD_DRV pfet_06v0 L=0.55U W=10U nf=1 ad=5P as=2.9P pd=21U ps=10.58U m=1
X43 x1_nbuf1 x1_ncb VDD_DRV VDD_DRV pfet_06v0 L=0.55U W=5U nf=1 ad=2.5P as=2.5P pd=11U ps=11U m=1
X44 x1_nca x1_ncb VDD_DRV VDD_DRV pfet_06v0 L=0.55U W=3U nf=1 ad=1.5P as=1.5P pd=7U ps=7U m=1
X45 x1_ncb x1_nca VDD_DRV VDD_DRV pfet_06v0 L=0.55U W=3U nf=1 ad=1.5P as=1.5P pd=7U ps=7U m=1
X46 x2_n1 IN_DRV VDD_DRV VDD_DRV pfet_06v0 L=0.55U W=4.4U nf=1 ad=2.2P as=2.2P pd=9.8U ps=9.8U m=1
X47 x2_n2 x2_n1 VDD_DRV VDD_DRV pfet_06v0 L=0.55U W=18U nf=1 ad=9P as=9P pd=37U ps=37U m=1
X48 x2_n3 x2_n2 VDD_DRV VDD_DRV pfet_06v0 L=0.55U W=73U nf=1 ad=36.5P as=36.5P pd=147U ps=147U m=1
X49 x2_n4 x2_n3 VDD_DRV VDD_DRV pfet_06v0 L=0.55U W=10U nf=1 ad=2.9P as=2.9P pd=10.58U ps=10.58U m=14
X50 x2_n4 x2_n3 VDD_DRV VDD_DRV pfet_06v0 L=0.55U W=10U nf=1 ad=2.9P as=5P pd=10.58U ps=21U m=1
X51 x2_n5 x2_n4 VDD_DRV VDD_DRV pfet_06v0 L=0.55U W=10U nf=1 ad=2.9P as=2.9P pd=10.58U ps=10.58U m=60
X52 x2_n5 x2_n4 VDD_DRV VDD_DRV pfet_06v0 L=0.55U W=10U nf=1 ad=2.9P as=5P pd=10.58U ps=21U m=1
X53 x3_lockout x3_ncompn VDD_DRV VDD_DRV pfet_06v0 L=0.55U W=10U nf=1 ad=5P as=5P pd=21U ps=21U m=1
X54 x3_ncompn x3_ncompp VDD_DRV VDD_DRV pfet_06v0 L=0.55U W=15U nf=1 ad=7.5P as=7.5P pd=31U ps=31U m=1
X55 x3_ncompp x3_ncompp VDD_DRV VDD_DRV pfet_06v0 L=0.55U W=15U nf=1 ad=7.5P as=7.5P pd=31U ps=31U m=1
X56 x3_uvlo_ok x3_lockout VDD_DRV VDD_DRV pfet_06v0 L=0.55U W=20U nf=1 ad=10P as=10P pd=41U ps=41U m=1

* T7: passive cards (CAP_CLASSES devices -- issue #166's XCCOMP stack)
C1770 x1_ncb ANON293 5.4516e-14
C1771 ANON294 ANON293 5.4516e-14
C1772 ANON294 ANON295 5.4516e-14
C1773 IN_DRV ANON295 5.4516e-14

* T9: passive cards (RES_CLASSES devices -- issue #221/#222's uvlo bias-resistor network)
R1774 VDD_DRV ANON21 66666.7
R1775 ANON21 ANON23 66666.7
R1776 ANON23 ANON24 66666.7
R1777 ANON24 ANON27 66666.7
R1778 ANON27 ANON28 66666.7
R1779 ANON28 ANON30 66666.7
R1780 x3_nref ANON20 66666.7
R1781 ANON20 ANON22 66666.7
R1782 ANON22 ANON25 66666.7
R1783 ANON25 ANON26 66666.7
R1784 ANON26 ANON29 66666.7
R1785 ANON29 ANON30 66666.7
R1786 VDD_DRV ANON31 55000
R1787 ANON31 ANON32 55000
R1788 ANON32 ANON33 55000
R1789 ANON33 ANON34 55000
R1790 ANON34 ANON35 55000
R1791 ANON35 ANON36 55000
R1792 ANON36 ANON37 55000
R1793 ANON37 ANON45 55000
R1794 x3_ndiv ANON38 55000
R1795 ANON38 ANON39 55000
R1796 ANON39 ANON40 55000
R1797 ANON40 ANON41 55000
R1798 ANON41 ANON42 55000
R1799 ANON42 ANON43 55000
R1800 ANON43 ANON44 55000
R1801 ANON44 ANON45 55000
R1802 x3_uvlo_ok ANON48 66666.7
R1803 x3_ndiv ANON46 66666.7
R1804 ANON46 ANON47 66666.7
R1805 ANON48 ANON49 66666.7
R1806 ANON49 ANON50 66666.7
R1807 ANON47 GND_DRV 66666.7
R1808 ANON50 ANON51 66666.7
R1809 ANON51 ANON52 66666.7
R1810 ANON52 ANON53 66666.7
R1811 ANON53 ANON54 66666.7
R1812 ANON54 ANON55 66666.7
R1813 ANON56 ANON57 66666.7
R1814 ANON56 ANON58 66666.7
R1815 ANON57 ANON59 66666.7
R1816 ANON58 ANON60 66666.7
R1817 ANON59 ANON62 66666.7
R1818 ANON60 ANON61 66666.7
R1819 ANON62 ANON64 66666.7
R1820 ANON61 ANON63 66666.7
R1821 ANON64 ANON65 66666.7
R1822 ANON63 ANON66 66666.7
R1823 ANON66 ANON67 66666.7
R1824 ANON65 ANON68 66666.7
R1825 ANON67 ANON69 66666.7
R1826 ANON68 ANON70 66666.7
R1827 ANON70 ANON55 66666.7
R1828 ANON69 ANON71 66666.7
R1829 ANON72 ANON73 66666.7
R1830 ANON72 ANON74 66666.7
R1831 ANON73 ANON75 66666.7
R1832 ANON74 ANON76 66666.7
R1833 ANON75 ANON77 66666.7
R1834 ANON76 ANON78 66666.7
R1835 ANON78 ANON80 66666.7
R1836 ANON77 ANON79 66666.7
R1837 ANON80 ANON82 66666.7
R1838 ANON79 ANON81 66666.7
R1839 ANON82 ANON84 66666.7
R1840 ANON81 ANON83 66666.7
R1841 ANON84 ANON86 66666.7
R1842 ANON83 ANON85 66666.7
R1843 ANON85 ANON71 66666.7
R1844 ANON86 ANON102 66666.7
R1845 ANON87 ANON88 66666.7
R1846 ANON88 ANON90 66666.7
R1847 ANON90 ANON92 66666.7
R1848 ANON92 ANON94 66666.7
R1849 ANON94 ANON96 66666.7
R1850 ANON96 ANON98 66666.7
R1851 ANON98 ANON100 66666.7
R1852 ANON100 ANON102 66666.7
R1853 ANON87 ANON89 66666.7
R1854 ANON89 ANON91 66666.7
R1855 ANON91 ANON93 66666.7
R1856 ANON93 ANON95 66666.7
R1857 ANON95 ANON97 66666.7
R1858 ANON97 ANON99 66666.7
R1859 ANON99 ANON101 66666.7
R1860 ANON101 ANON118 66666.7
R1861 ANON103 ANON104 66666.7
R1862 ANON104 ANON106 66666.7
R1863 ANON106 ANON108 66666.7
R1864 ANON108 ANON110 66666.7
R1865 ANON110 ANON112 66666.7
R1866 ANON112 ANON114 66666.7
R1867 ANON114 ANON116 66666.7
R1868 ANON116 ANON118 66666.7
R1869 ANON103 ANON105 66666.7
R1870 ANON105 ANON107 66666.7
R1871 ANON107 ANON109 66666.7
R1872 ANON109 ANON111 66666.7
R1873 ANON111 ANON113 66666.7
R1874 ANON113 ANON115 66666.7
R1875 ANON115 ANON117 66666.7
R1876 ANON117 ANON134 66666.7
R1877 ANON119 ANON120 66666.7
R1878 ANON120 ANON122 66666.7
R1879 ANON122 ANON124 66666.7
R1880 ANON124 ANON126 66666.7
R1881 ANON126 ANON128 66666.7
R1882 ANON128 ANON130 66666.7
R1883 ANON130 ANON132 66666.7
R1884 ANON132 ANON134 66666.7
R1885 ANON119 ANON121 66666.7
R1886 ANON121 ANON123 66666.7
R1887 ANON123 ANON125 66666.7
R1888 ANON125 ANON127 66666.7
R1889 ANON127 ANON129 66666.7
R1890 ANON129 ANON131 66666.7
R1891 ANON131 ANON133 66666.7
R1892 ANON133 ANON150 66666.7
R1893 ANON135 ANON137 66666.7
R1894 ANON135 ANON136 66666.7
R1895 ANON137 ANON139 66666.7
R1896 ANON136 ANON138 66666.7
R1897 ANON139 ANON141 66666.7
R1898 ANON138 ANON140 66666.7
R1899 ANON141 ANON143 66666.7
R1900 ANON140 ANON142 66666.7
R1901 ANON142 ANON144 66666.7
R1902 ANON143 ANON145 66666.7
R1903 ANON144 ANON146 66666.7
R1904 ANON145 ANON147 66666.7
R1905 ANON147 ANON149 66666.7
R1906 ANON146 ANON148 66666.7
R1907 ANON149 ANON166 66666.7
R1908 ANON148 ANON150 66666.7
R1909 ANON151 ANON152 66666.7
R1910 ANON151 ANON153 66666.7
R1911 ANON152 ANON154 66666.7
R1912 ANON153 ANON155 66666.7
R1913 ANON154 ANON156 66666.7
R1914 ANON155 ANON157 66666.7
R1915 ANON157 ANON159 66666.7
R1916 ANON156 ANON158 66666.7
R1917 ANON159 ANON161 66666.7
R1918 ANON158 ANON160 66666.7
R1919 ANON161 ANON163 66666.7
R1920 ANON160 ANON162 66666.7
R1921 ANON163 ANON165 66666.7
R1922 ANON162 ANON164 66666.7
R1923 ANON165 ANON182 66666.7
R1924 ANON164 ANON166 66666.7
R1925 ANON167 ANON169 66666.7
R1926 ANON167 ANON168 66666.7
R1927 ANON168 ANON170 66666.7
R1928 ANON169 ANON171 66666.7
R1929 ANON171 ANON173 66666.7
R1930 ANON170 ANON172 66666.7
R1931 ANON173 ANON175 66666.7
R1932 ANON172 ANON174 66666.7
R1933 ANON174 ANON176 66666.7
R1934 ANON175 ANON177 66666.7
R1935 ANON177 ANON179 66666.7
R1936 ANON176 ANON178 66666.7
R1937 ANON178 ANON180 66666.7
R1938 ANON179 ANON181 66666.7
R1939 ANON181 ANON198 66666.7
R1940 ANON180 ANON182 66666.7
R1941 ANON183 ANON185 66666.7
R1942 ANON183 ANON184 66666.7
R1943 ANON184 ANON186 66666.7
R1944 ANON185 ANON187 66666.7
R1945 ANON187 ANON189 66666.7
R1946 ANON186 ANON188 66666.7
R1947 ANON188 ANON190 66666.7
R1948 ANON189 ANON191 66666.7
R1949 ANON191 ANON193 66666.7
R1950 ANON190 ANON192 66666.7
R1951 ANON193 ANON195 66666.7
R1952 ANON192 ANON194 66666.7
R1953 ANON194 ANON196 66666.7
R1954 ANON195 ANON197 66666.7
R1955 ANON197 ANON214 66666.7
R1956 ANON196 ANON198 66666.7
R1957 ANON199 ANON200 66666.7
R1958 ANON199 ANON201 66666.7
R1959 ANON200 ANON202 66666.7
R1960 ANON201 ANON203 66666.7
R1961 ANON203 ANON205 66666.7
R1962 ANON202 ANON204 66666.7
R1963 ANON204 ANON206 66666.7
R1964 ANON205 ANON207 66666.7
R1965 ANON207 ANON209 66666.7
R1966 ANON206 ANON208 66666.7
R1967 ANON208 ANON210 66666.7
R1968 ANON209 ANON211 66666.7
R1969 ANON210 ANON212 66666.7
R1970 ANON211 ANON213 66666.7
R1971 ANON213 ANON230 66666.7
R1972 ANON212 ANON214 66666.7
R1973 ANON215 ANON216 66666.7
R1974 ANON215 ANON217 66666.7
R1975 ANON217 ANON219 66666.7
R1976 ANON216 ANON218 66666.7
R1977 ANON219 ANON221 66666.7
R1978 ANON218 ANON220 66666.7
R1979 ANON220 ANON222 66666.7
R1980 ANON221 ANON223 66666.7
R1981 ANON222 ANON224 66666.7
R1982 ANON223 ANON225 66666.7
R1983 ANON224 ANON226 66666.7
R1984 ANON225 ANON227 66666.7
R1985 ANON226 ANON228 66666.7
R1986 ANON227 ANON229 66666.7
R1987 ANON229 ANON246 66666.7
R1988 ANON228 ANON230 66666.7
R1989 ANON231 ANON233 66666.7
R1990 ANON231 ANON232 66666.7
R1991 ANON232 ANON234 66666.7
R1992 ANON233 ANON235 66666.7
R1993 ANON235 ANON237 66666.7
R1994 ANON234 ANON236 66666.7
R1995 ANON237 ANON239 66666.7
R1996 ANON236 ANON238 66666.7
R1997 ANON238 ANON240 66666.7
R1998 ANON239 ANON241 66666.7
R1999 ANON240 ANON242 66666.7
R2000 ANON241 ANON243 66666.7
R2001 ANON242 ANON244 66666.7
R2002 ANON243 ANON245 66666.7
R2003 ANON245 ANON262 66666.7
R2004 ANON244 ANON246 66666.7
R2005 ANON247 ANON248 66666.7
R2006 ANON247 ANON249 66666.7
R2007 ANON248 ANON250 66666.7
R2008 ANON249 ANON251 66666.7
R2009 ANON250 ANON252 66666.7
R2010 ANON251 ANON253 66666.7
R2011 ANON252 ANON254 66666.7
R2012 ANON253 ANON255 66666.7
R2013 ANON254 ANON256 66666.7
R2014 ANON255 ANON257 66666.7
R2015 ANON256 ANON258 66666.7
R2016 ANON257 ANON259 66666.7
R2017 ANON258 ANON260 66666.7
R2018 ANON259 ANON261 66666.7
R2019 ANON261 ANON278 66666.7
R2020 ANON260 ANON262 66666.7
R2021 ANON263 ANON264 66666.7
R2022 ANON263 ANON265 66666.7
R2023 ANON265 ANON267 66666.7
R2024 ANON264 ANON266 66666.7
R2025 ANON266 ANON268 66666.7
R2026 ANON267 ANON269 66666.7
R2027 ANON269 ANON271 66666.7
R2028 ANON268 ANON270 66666.7
R2029 ANON270 ANON272 66666.7
R2030 ANON271 ANON273 66666.7
R2031 ANON272 ANON274 66666.7
R2032 ANON273 ANON275 66666.7
R2033 ANON274 ANON276 66666.7
R2034 ANON275 ANON277 66666.7
R2035 ANON277 ANON286 66666.7
R2036 ANON276 ANON278 66666.7
R2037 x3_ndiv ANON279 66666.7
R2038 ANON279 ANON280 66666.7
R2039 ANON280 ANON281 66666.7
R2040 ANON281 ANON282 66666.7
R2041 ANON282 ANON283 66666.7
R2042 ANON283 ANON284 66666.7
R2043 ANON284 ANON285 66666.7
R2044 ANON285 ANON286 66666.7
