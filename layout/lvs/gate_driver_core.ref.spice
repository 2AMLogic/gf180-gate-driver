* LVS reference netlist for gate_driver_core -- GENERATED, do not edit.
*
* Produced by layout/lvs/make_reference.py from
* design/netlist/gate_driver_core.spice via
* layout/gen_gate_driver_core.py's own parse_netlist_full(), applying the
* seven mechanical transforms documented in that script's module docstring.
*
* MOS devices: 1105 nfet + 664 pfet (35 schematic instances, expanded to drawn finger count)
* MiM caps  : 4 (4 schematic instances, 1:1 -- one drawn plate pair each)
* Resistors : 271 ppolyf_u (4 schematic instances, 1:1 -- one folded res_array block each)

.SUBCKT gate_driver_core GND_DRV GND_LOGIC IN IN_DRV OUT VDD_DRV VDD_LOGIC x1_inb x1_na x1_nb x1_nbuf1 x1_nca x1_ncb x2_n1 x2_n2 x2_n3 x2_n4 x2_n5 x3_lockout x3_ncompn x3_ncompp x3_ndiv x3_nref x3_ntail x3_uvlo_ok
Cx1_XCCOMP1 x1_ncb x1_nccomp1 cap_mim_2f0_m4m5_noshield C=5.4516e-14
Cx1_XCCOMP2 x1_nccomp1 x1_nccomp2 cap_mim_2f0_m4m5_noshield C=5.4516e-14
Cx1_XCCOMP3 x1_nccomp2 x1_nccomp3 cap_mim_2f0_m4m5_noshield C=5.4516e-14
Cx1_XCCOMP4 x1_nccomp3 IN_DRV cap_mim_2f0_m4m5_noshield C=5.4516e-14
Mx1_XMNBUF1_0 x1_nbuf1 x1_ncb GND_DRV GND_LOGIC nfet L=0.7U W=5U
Mx1_XMNBUF2_0 IN_DRV x1_nbuf1 GND_DRV GND_LOGIC nfet L=0.7U W=15U
Mx1_XMNCASA_0 x1_nca VDD_LOGIC x1_na GND_LOGIC nfet L=0.7U W=20U
Mx1_XMNCASB_0 x1_ncb VDD_LOGIC x1_nb GND_LOGIC nfet L=0.7U W=20U
Mx1_XMNINV_0 x1_inb IN GND_LOGIC GND_LOGIC nfet L=0.28U W=5U
Mx1_XMNPDA_0 x1_na IN GND_LOGIC GND_LOGIC nfet L=0.28U W=20U
Mx1_XMNPDB_0 x1_nb x1_inb GND_LOGIC GND_LOGIC nfet L=0.28U W=20U
Mx1_XMPBUF1_0 x1_nbuf1 x1_ncb VDD_DRV VDD_DRV pfet L=0.55U W=5U
Mx1_XMPBUF2_0 IN_DRV x1_nbuf1 VDD_DRV VDD_DRV pfet L=0.55U W=15U
Mx1_XMPINV_0 x1_inb IN VDD_LOGIC VDD_LOGIC pfet L=0.28U W=10U
Mx1_XMPLATA_0 x1_nca x1_ncb VDD_DRV VDD_DRV pfet L=0.55U W=3U
Mx1_XMPLATB_0 x1_ncb x1_nca VDD_DRV VDD_DRV pfet L=0.55U W=3U
Mx2_XMN1_0 x2_n1 IN_DRV GND_DRV GND_LOGIC nfet L=0.7U W=2U
Mx2_XMN2_0 x2_n2 x2_n1 GND_DRV GND_LOGIC nfet L=0.7U W=8U
Mx2_XMN3_0 x2_n3 x2_n2 GND_DRV GND_LOGIC nfet L=0.7U W=33U
Mx2_XMN4_0 x2_n4 x2_n3 GND_DRV GND_LOGIC nfet L=0.7U W=10U
Mx2_XMN4_1 x2_n4 x2_n3 GND_DRV GND_LOGIC nfet L=0.7U W=10U
Mx2_XMN4_10 x2_n4 x2_n3 GND_DRV GND_LOGIC nfet L=0.7U W=10U
Mx2_XMN4_11 x2_n4 x2_n3 GND_DRV GND_LOGIC nfet L=0.7U W=10U
Mx2_XMN4_12 x2_n4 x2_n3 GND_DRV GND_LOGIC nfet L=0.7U W=10U
Mx2_XMN4_13 x2_n4 x2_n3 GND_DRV GND_LOGIC nfet L=0.7U W=10U
Mx2_XMN4_2 x2_n4 x2_n3 GND_DRV GND_LOGIC nfet L=0.7U W=10U
Mx2_XMN4_3 x2_n4 x2_n3 GND_DRV GND_LOGIC nfet L=0.7U W=10U
Mx2_XMN4_4 x2_n4 x2_n3 GND_DRV GND_LOGIC nfet L=0.7U W=10U
Mx2_XMN4_5 x2_n4 x2_n3 GND_DRV GND_LOGIC nfet L=0.7U W=10U
Mx2_XMN4_6 x2_n4 x2_n3 GND_DRV GND_LOGIC nfet L=0.7U W=10U
Mx2_XMN4_7 x2_n4 x2_n3 GND_DRV GND_LOGIC nfet L=0.7U W=10U
Mx2_XMN4_8 x2_n4 x2_n3 GND_DRV GND_LOGIC nfet L=0.7U W=10U
Mx2_XMN4_9 x2_n4 x2_n3 GND_DRV GND_LOGIC nfet L=0.7U W=10U
Mx2_XMN5_0 x2_n5 x2_n4 GND_DRV GND_LOGIC nfet L=0.7U W=10U
Mx2_XMN5_1 x2_n5 x2_n4 GND_DRV GND_LOGIC nfet L=0.7U W=10U
Mx2_XMN5_10 x2_n5 x2_n4 GND_DRV GND_LOGIC nfet L=0.7U W=10U
Mx2_XMN5_11 x2_n5 x2_n4 GND_DRV GND_LOGIC nfet L=0.7U W=10U
Mx2_XMN5_12 x2_n5 x2_n4 GND_DRV GND_LOGIC nfet L=0.7U W=10U
Mx2_XMN5_13 x2_n5 x2_n4 GND_DRV GND_LOGIC nfet L=0.7U W=10U
Mx2_XMN5_14 x2_n5 x2_n4 GND_DRV GND_LOGIC nfet L=0.7U W=10U
Mx2_XMN5_15 x2_n5 x2_n4 GND_DRV GND_LOGIC nfet L=0.7U W=10U
Mx2_XMN5_16 x2_n5 x2_n4 GND_DRV GND_LOGIC nfet L=0.7U W=10U
Mx2_XMN5_17 x2_n5 x2_n4 GND_DRV GND_LOGIC nfet L=0.7U W=10U
Mx2_XMN5_18 x2_n5 x2_n4 GND_DRV GND_LOGIC nfet L=0.7U W=10U
Mx2_XMN5_19 x2_n5 x2_n4 GND_DRV GND_LOGIC nfet L=0.7U W=10U
Mx2_XMN5_2 x2_n5 x2_n4 GND_DRV GND_LOGIC nfet L=0.7U W=10U
Mx2_XMN5_20 x2_n5 x2_n4 GND_DRV GND_LOGIC nfet L=0.7U W=10U
Mx2_XMN5_21 x2_n5 x2_n4 GND_DRV GND_LOGIC nfet L=0.7U W=10U
Mx2_XMN5_22 x2_n5 x2_n4 GND_DRV GND_LOGIC nfet L=0.7U W=10U
Mx2_XMN5_23 x2_n5 x2_n4 GND_DRV GND_LOGIC nfet L=0.7U W=10U
Mx2_XMN5_24 x2_n5 x2_n4 GND_DRV GND_LOGIC nfet L=0.7U W=10U
Mx2_XMN5_25 x2_n5 x2_n4 GND_DRV GND_LOGIC nfet L=0.7U W=10U
Mx2_XMN5_26 x2_n5 x2_n4 GND_DRV GND_LOGIC nfet L=0.7U W=10U
Mx2_XMN5_27 x2_n5 x2_n4 GND_DRV GND_LOGIC nfet L=0.7U W=10U
Mx2_XMN5_28 x2_n5 x2_n4 GND_DRV GND_LOGIC nfet L=0.7U W=10U
Mx2_XMN5_29 x2_n5 x2_n4 GND_DRV GND_LOGIC nfet L=0.7U W=10U
Mx2_XMN5_3 x2_n5 x2_n4 GND_DRV GND_LOGIC nfet L=0.7U W=10U
Mx2_XMN5_30 x2_n5 x2_n4 GND_DRV GND_LOGIC nfet L=0.7U W=10U
Mx2_XMN5_31 x2_n5 x2_n4 GND_DRV GND_LOGIC nfet L=0.7U W=10U
Mx2_XMN5_32 x2_n5 x2_n4 GND_DRV GND_LOGIC nfet L=0.7U W=10U
Mx2_XMN5_33 x2_n5 x2_n4 GND_DRV GND_LOGIC nfet L=0.7U W=10U
Mx2_XMN5_34 x2_n5 x2_n4 GND_DRV GND_LOGIC nfet L=0.7U W=10U
Mx2_XMN5_35 x2_n5 x2_n4 GND_DRV GND_LOGIC nfet L=0.7U W=10U
Mx2_XMN5_36 x2_n5 x2_n4 GND_DRV GND_LOGIC nfet L=0.7U W=10U
Mx2_XMN5_37 x2_n5 x2_n4 GND_DRV GND_LOGIC nfet L=0.7U W=10U
Mx2_XMN5_38 x2_n5 x2_n4 GND_DRV GND_LOGIC nfet L=0.7U W=10U
Mx2_XMN5_39 x2_n5 x2_n4 GND_DRV GND_LOGIC nfet L=0.7U W=10U
Mx2_XMN5_4 x2_n5 x2_n4 GND_DRV GND_LOGIC nfet L=0.7U W=10U
Mx2_XMN5_40 x2_n5 x2_n4 GND_DRV GND_LOGIC nfet L=0.7U W=10U
Mx2_XMN5_41 x2_n5 x2_n4 GND_DRV GND_LOGIC nfet L=0.7U W=10U
Mx2_XMN5_42 x2_n5 x2_n4 GND_DRV GND_LOGIC nfet L=0.7U W=10U
Mx2_XMN5_43 x2_n5 x2_n4 GND_DRV GND_LOGIC nfet L=0.7U W=10U
Mx2_XMN5_44 x2_n5 x2_n4 GND_DRV GND_LOGIC nfet L=0.7U W=10U
Mx2_XMN5_45 x2_n5 x2_n4 GND_DRV GND_LOGIC nfet L=0.7U W=10U
Mx2_XMN5_46 x2_n5 x2_n4 GND_DRV GND_LOGIC nfet L=0.7U W=10U
Mx2_XMN5_47 x2_n5 x2_n4 GND_DRV GND_LOGIC nfet L=0.7U W=10U
Mx2_XMN5_48 x2_n5 x2_n4 GND_DRV GND_LOGIC nfet L=0.7U W=10U
Mx2_XMN5_49 x2_n5 x2_n4 GND_DRV GND_LOGIC nfet L=0.7U W=10U
Mx2_XMN5_5 x2_n5 x2_n4 GND_DRV GND_LOGIC nfet L=0.7U W=10U
Mx2_XMN5_50 x2_n5 x2_n4 GND_DRV GND_LOGIC nfet L=0.7U W=10U
Mx2_XMN5_51 x2_n5 x2_n4 GND_DRV GND_LOGIC nfet L=0.7U W=10U
Mx2_XMN5_52 x2_n5 x2_n4 GND_DRV GND_LOGIC nfet L=0.7U W=10U
Mx2_XMN5_53 x2_n5 x2_n4 GND_DRV GND_LOGIC nfet L=0.7U W=10U
Mx2_XMN5_54 x2_n5 x2_n4 GND_DRV GND_LOGIC nfet L=0.7U W=10U
Mx2_XMN5_6 x2_n5 x2_n4 GND_DRV GND_LOGIC nfet L=0.7U W=10U
Mx2_XMN5_7 x2_n5 x2_n4 GND_DRV GND_LOGIC nfet L=0.7U W=10U
Mx2_XMN5_8 x2_n5 x2_n4 GND_DRV GND_LOGIC nfet L=0.7U W=10U
Mx2_XMN5_9 x2_n5 x2_n4 GND_DRV GND_LOGIC nfet L=0.7U W=10U
Mx2_XMN6_0 OUT x2_n5 GND_DRV GND_LOGIC nfet L=0.7U W=10U
Mx2_XMN6_1 OUT x2_n5 GND_DRV GND_LOGIC nfet L=0.7U W=10U
Mx2_XMN6_10 OUT x2_n5 GND_DRV GND_LOGIC nfet L=0.7U W=10U
Mx2_XMN6_100 OUT x2_n5 GND_DRV GND_LOGIC nfet L=0.7U W=10U
Mx2_XMN6_101 OUT x2_n5 GND_DRV GND_LOGIC nfet L=0.7U W=10U
Mx2_XMN6_102 OUT x2_n5 GND_DRV GND_LOGIC nfet L=0.7U W=10U
Mx2_XMN6_103 OUT x2_n5 GND_DRV GND_LOGIC nfet L=0.7U W=10U
Mx2_XMN6_104 OUT x2_n5 GND_DRV GND_LOGIC nfet L=0.7U W=10U
Mx2_XMN6_105 OUT x2_n5 GND_DRV GND_LOGIC nfet L=0.7U W=10U
Mx2_XMN6_106 OUT x2_n5 GND_DRV GND_LOGIC nfet L=0.7U W=10U
Mx2_XMN6_107 OUT x2_n5 GND_DRV GND_LOGIC nfet L=0.7U W=10U
Mx2_XMN6_108 OUT x2_n5 GND_DRV GND_LOGIC nfet L=0.7U W=10U
Mx2_XMN6_109 OUT x2_n5 GND_DRV GND_LOGIC nfet L=0.7U W=10U
Mx2_XMN6_11 OUT x2_n5 GND_DRV GND_LOGIC nfet L=0.7U W=10U
Mx2_XMN6_110 OUT x2_n5 GND_DRV GND_LOGIC nfet L=0.7U W=10U
Mx2_XMN6_111 OUT x2_n5 GND_DRV GND_LOGIC nfet L=0.7U W=10U
Mx2_XMN6_112 OUT x2_n5 GND_DRV GND_LOGIC nfet L=0.7U W=10U
Mx2_XMN6_113 OUT x2_n5 GND_DRV GND_LOGIC nfet L=0.7U W=10U
Mx2_XMN6_114 OUT x2_n5 GND_DRV GND_LOGIC nfet L=0.7U W=10U
Mx2_XMN6_115 OUT x2_n5 GND_DRV GND_LOGIC nfet L=0.7U W=10U
Mx2_XMN6_116 OUT x2_n5 GND_DRV GND_LOGIC nfet L=0.7U W=10U
Mx2_XMN6_117 OUT x2_n5 GND_DRV GND_LOGIC nfet L=0.7U W=10U
Mx2_XMN6_118 OUT x2_n5 GND_DRV GND_LOGIC nfet L=0.7U W=10U
Mx2_XMN6_119 OUT x2_n5 GND_DRV GND_LOGIC nfet L=0.7U W=10U
Mx2_XMN6_12 OUT x2_n5 GND_DRV GND_LOGIC nfet L=0.7U W=10U
Mx2_XMN6_120 OUT x2_n5 GND_DRV GND_LOGIC nfet L=0.7U W=10U
Mx2_XMN6_121 OUT x2_n5 GND_DRV GND_LOGIC nfet L=0.7U W=10U
Mx2_XMN6_122 OUT x2_n5 GND_DRV GND_LOGIC nfet L=0.7U W=10U
Mx2_XMN6_123 OUT x2_n5 GND_DRV GND_LOGIC nfet L=0.7U W=10U
Mx2_XMN6_124 OUT x2_n5 GND_DRV GND_LOGIC nfet L=0.7U W=10U
Mx2_XMN6_125 OUT x2_n5 GND_DRV GND_LOGIC nfet L=0.7U W=10U
Mx2_XMN6_126 OUT x2_n5 GND_DRV GND_LOGIC nfet L=0.7U W=10U
Mx2_XMN6_127 OUT x2_n5 GND_DRV GND_LOGIC nfet L=0.7U W=10U
Mx2_XMN6_128 OUT x2_n5 GND_DRV GND_LOGIC nfet L=0.7U W=10U
Mx2_XMN6_129 OUT x2_n5 GND_DRV GND_LOGIC nfet L=0.7U W=10U
Mx2_XMN6_13 OUT x2_n5 GND_DRV GND_LOGIC nfet L=0.7U W=10U
Mx2_XMN6_130 OUT x2_n5 GND_DRV GND_LOGIC nfet L=0.7U W=10U
Mx2_XMN6_131 OUT x2_n5 GND_DRV GND_LOGIC nfet L=0.7U W=10U
Mx2_XMN6_132 OUT x2_n5 GND_DRV GND_LOGIC nfet L=0.7U W=10U
Mx2_XMN6_133 OUT x2_n5 GND_DRV GND_LOGIC nfet L=0.7U W=10U
Mx2_XMN6_134 OUT x2_n5 GND_DRV GND_LOGIC nfet L=0.7U W=10U
Mx2_XMN6_135 OUT x2_n5 GND_DRV GND_LOGIC nfet L=0.7U W=10U
Mx2_XMN6_136 OUT x2_n5 GND_DRV GND_LOGIC nfet L=0.7U W=10U
Mx2_XMN6_137 OUT x2_n5 GND_DRV GND_LOGIC nfet L=0.7U W=10U
Mx2_XMN6_138 OUT x2_n5 GND_DRV GND_LOGIC nfet L=0.7U W=10U
Mx2_XMN6_139 OUT x2_n5 GND_DRV GND_LOGIC nfet L=0.7U W=10U
Mx2_XMN6_14 OUT x2_n5 GND_DRV GND_LOGIC nfet L=0.7U W=10U
Mx2_XMN6_140 OUT x2_n5 GND_DRV GND_LOGIC nfet L=0.7U W=10U
Mx2_XMN6_141 OUT x2_n5 GND_DRV GND_LOGIC nfet L=0.7U W=10U
Mx2_XMN6_142 OUT x2_n5 GND_DRV GND_LOGIC nfet L=0.7U W=10U
Mx2_XMN6_143 OUT x2_n5 GND_DRV GND_LOGIC nfet L=0.7U W=10U
Mx2_XMN6_144 OUT x2_n5 GND_DRV GND_LOGIC nfet L=0.7U W=10U
Mx2_XMN6_145 OUT x2_n5 GND_DRV GND_LOGIC nfet L=0.7U W=10U
Mx2_XMN6_146 OUT x2_n5 GND_DRV GND_LOGIC nfet L=0.7U W=10U
Mx2_XMN6_147 OUT x2_n5 GND_DRV GND_LOGIC nfet L=0.7U W=10U
Mx2_XMN6_148 OUT x2_n5 GND_DRV GND_LOGIC nfet L=0.7U W=10U
Mx2_XMN6_149 OUT x2_n5 GND_DRV GND_LOGIC nfet L=0.7U W=10U
Mx2_XMN6_15 OUT x2_n5 GND_DRV GND_LOGIC nfet L=0.7U W=10U
Mx2_XMN6_150 OUT x2_n5 GND_DRV GND_LOGIC nfet L=0.7U W=10U
Mx2_XMN6_151 OUT x2_n5 GND_DRV GND_LOGIC nfet L=0.7U W=10U
Mx2_XMN6_152 OUT x2_n5 GND_DRV GND_LOGIC nfet L=0.7U W=10U
Mx2_XMN6_153 OUT x2_n5 GND_DRV GND_LOGIC nfet L=0.7U W=10U
Mx2_XMN6_154 OUT x2_n5 GND_DRV GND_LOGIC nfet L=0.7U W=10U
Mx2_XMN6_155 OUT x2_n5 GND_DRV GND_LOGIC nfet L=0.7U W=10U
Mx2_XMN6_156 OUT x2_n5 GND_DRV GND_LOGIC nfet L=0.7U W=10U
Mx2_XMN6_157 OUT x2_n5 GND_DRV GND_LOGIC nfet L=0.7U W=10U
Mx2_XMN6_158 OUT x2_n5 GND_DRV GND_LOGIC nfet L=0.7U W=10U
Mx2_XMN6_159 OUT x2_n5 GND_DRV GND_LOGIC nfet L=0.7U W=10U
Mx2_XMN6_16 OUT x2_n5 GND_DRV GND_LOGIC nfet L=0.7U W=10U
Mx2_XMN6_160 OUT x2_n5 GND_DRV GND_LOGIC nfet L=0.7U W=10U
Mx2_XMN6_161 OUT x2_n5 GND_DRV GND_LOGIC nfet L=0.7U W=10U
Mx2_XMN6_162 OUT x2_n5 GND_DRV GND_LOGIC nfet L=0.7U W=10U
Mx2_XMN6_163 OUT x2_n5 GND_DRV GND_LOGIC nfet L=0.7U W=10U
Mx2_XMN6_164 OUT x2_n5 GND_DRV GND_LOGIC nfet L=0.7U W=10U
Mx2_XMN6_165 OUT x2_n5 GND_DRV GND_LOGIC nfet L=0.7U W=10U
Mx2_XMN6_166 OUT x2_n5 GND_DRV GND_LOGIC nfet L=0.7U W=10U
Mx2_XMN6_167 OUT x2_n5 GND_DRV GND_LOGIC nfet L=0.7U W=10U
Mx2_XMN6_168 OUT x2_n5 GND_DRV GND_LOGIC nfet L=0.7U W=10U
Mx2_XMN6_169 OUT x2_n5 GND_DRV GND_LOGIC nfet L=0.7U W=10U
Mx2_XMN6_17 OUT x2_n5 GND_DRV GND_LOGIC nfet L=0.7U W=10U
Mx2_XMN6_170 OUT x2_n5 GND_DRV GND_LOGIC nfet L=0.7U W=10U
Mx2_XMN6_171 OUT x2_n5 GND_DRV GND_LOGIC nfet L=0.7U W=10U
Mx2_XMN6_172 OUT x2_n5 GND_DRV GND_LOGIC nfet L=0.7U W=10U
Mx2_XMN6_173 OUT x2_n5 GND_DRV GND_LOGIC nfet L=0.7U W=10U
Mx2_XMN6_174 OUT x2_n5 GND_DRV GND_LOGIC nfet L=0.7U W=10U
Mx2_XMN6_175 OUT x2_n5 GND_DRV GND_LOGIC nfet L=0.7U W=10U
Mx2_XMN6_176 OUT x2_n5 GND_DRV GND_LOGIC nfet L=0.7U W=10U
Mx2_XMN6_177 OUT x2_n5 GND_DRV GND_LOGIC nfet L=0.7U W=10U
Mx2_XMN6_178 OUT x2_n5 GND_DRV GND_LOGIC nfet L=0.7U W=10U
Mx2_XMN6_179 OUT x2_n5 GND_DRV GND_LOGIC nfet L=0.7U W=10U
Mx2_XMN6_18 OUT x2_n5 GND_DRV GND_LOGIC nfet L=0.7U W=10U
Mx2_XMN6_180 OUT x2_n5 GND_DRV GND_LOGIC nfet L=0.7U W=10U
Mx2_XMN6_181 OUT x2_n5 GND_DRV GND_LOGIC nfet L=0.7U W=10U
Mx2_XMN6_182 OUT x2_n5 GND_DRV GND_LOGIC nfet L=0.7U W=10U
Mx2_XMN6_183 OUT x2_n5 GND_DRV GND_LOGIC nfet L=0.7U W=10U
Mx2_XMN6_184 OUT x2_n5 GND_DRV GND_LOGIC nfet L=0.7U W=10U
Mx2_XMN6_185 OUT x2_n5 GND_DRV GND_LOGIC nfet L=0.7U W=10U
Mx2_XMN6_186 OUT x2_n5 GND_DRV GND_LOGIC nfet L=0.7U W=10U
Mx2_XMN6_187 OUT x2_n5 GND_DRV GND_LOGIC nfet L=0.7U W=10U
Mx2_XMN6_188 OUT x2_n5 GND_DRV GND_LOGIC nfet L=0.7U W=10U
Mx2_XMN6_189 OUT x2_n5 GND_DRV GND_LOGIC nfet L=0.7U W=10U
Mx2_XMN6_19 OUT x2_n5 GND_DRV GND_LOGIC nfet L=0.7U W=10U
Mx2_XMN6_190 OUT x2_n5 GND_DRV GND_LOGIC nfet L=0.7U W=10U
Mx2_XMN6_191 OUT x2_n5 GND_DRV GND_LOGIC nfet L=0.7U W=10U
Mx2_XMN6_192 OUT x2_n5 GND_DRV GND_LOGIC nfet L=0.7U W=10U
Mx2_XMN6_193 OUT x2_n5 GND_DRV GND_LOGIC nfet L=0.7U W=10U
Mx2_XMN6_194 OUT x2_n5 GND_DRV GND_LOGIC nfet L=0.7U W=10U
Mx2_XMN6_195 OUT x2_n5 GND_DRV GND_LOGIC nfet L=0.7U W=10U
Mx2_XMN6_196 OUT x2_n5 GND_DRV GND_LOGIC nfet L=0.7U W=10U
Mx2_XMN6_197 OUT x2_n5 GND_DRV GND_LOGIC nfet L=0.7U W=10U
Mx2_XMN6_198 OUT x2_n5 GND_DRV GND_LOGIC nfet L=0.7U W=10U
Mx2_XMN6_199 OUT x2_n5 GND_DRV GND_LOGIC nfet L=0.7U W=10U
Mx2_XMN6_2 OUT x2_n5 GND_DRV GND_LOGIC nfet L=0.7U W=10U
Mx2_XMN6_20 OUT x2_n5 GND_DRV GND_LOGIC nfet L=0.7U W=10U
Mx2_XMN6_200 OUT x2_n5 GND_DRV GND_LOGIC nfet L=0.7U W=10U
Mx2_XMN6_201 OUT x2_n5 GND_DRV GND_LOGIC nfet L=0.7U W=10U
Mx2_XMN6_202 OUT x2_n5 GND_DRV GND_LOGIC nfet L=0.7U W=10U
Mx2_XMN6_203 OUT x2_n5 GND_DRV GND_LOGIC nfet L=0.7U W=10U
Mx2_XMN6_204 OUT x2_n5 GND_DRV GND_LOGIC nfet L=0.7U W=10U
Mx2_XMN6_205 OUT x2_n5 GND_DRV GND_LOGIC nfet L=0.7U W=10U
Mx2_XMN6_206 OUT x2_n5 GND_DRV GND_LOGIC nfet L=0.7U W=10U
Mx2_XMN6_207 OUT x2_n5 GND_DRV GND_LOGIC nfet L=0.7U W=10U
Mx2_XMN6_208 OUT x2_n5 GND_DRV GND_LOGIC nfet L=0.7U W=10U
Mx2_XMN6_209 OUT x2_n5 GND_DRV GND_LOGIC nfet L=0.7U W=10U
Mx2_XMN6_21 OUT x2_n5 GND_DRV GND_LOGIC nfet L=0.7U W=10U
Mx2_XMN6_210 OUT x2_n5 GND_DRV GND_LOGIC nfet L=0.7U W=10U
Mx2_XMN6_211 OUT x2_n5 GND_DRV GND_LOGIC nfet L=0.7U W=10U
Mx2_XMN6_212 OUT x2_n5 GND_DRV GND_LOGIC nfet L=0.7U W=10U
Mx2_XMN6_213 OUT x2_n5 GND_DRV GND_LOGIC nfet L=0.7U W=10U
Mx2_XMN6_214 OUT x2_n5 GND_DRV GND_LOGIC nfet L=0.7U W=10U
Mx2_XMN6_215 OUT x2_n5 GND_DRV GND_LOGIC nfet L=0.7U W=10U
Mx2_XMN6_216 OUT x2_n5 GND_DRV GND_LOGIC nfet L=0.7U W=10U
Mx2_XMN6_217 OUT x2_n5 GND_DRV GND_LOGIC nfet L=0.7U W=10U
Mx2_XMN6_218 OUT x2_n5 GND_DRV GND_LOGIC nfet L=0.7U W=10U
Mx2_XMN6_219 OUT x2_n5 GND_DRV GND_LOGIC nfet L=0.7U W=10U
Mx2_XMN6_22 OUT x2_n5 GND_DRV GND_LOGIC nfet L=0.7U W=10U
Mx2_XMN6_23 OUT x2_n5 GND_DRV GND_LOGIC nfet L=0.7U W=10U
Mx2_XMN6_24 OUT x2_n5 GND_DRV GND_LOGIC nfet L=0.7U W=10U
Mx2_XMN6_25 OUT x2_n5 GND_DRV GND_LOGIC nfet L=0.7U W=10U
Mx2_XMN6_26 OUT x2_n5 GND_DRV GND_LOGIC nfet L=0.7U W=10U
Mx2_XMN6_27 OUT x2_n5 GND_DRV GND_LOGIC nfet L=0.7U W=10U
Mx2_XMN6_28 OUT x2_n5 GND_DRV GND_LOGIC nfet L=0.7U W=10U
Mx2_XMN6_29 OUT x2_n5 GND_DRV GND_LOGIC nfet L=0.7U W=10U
Mx2_XMN6_3 OUT x2_n5 GND_DRV GND_LOGIC nfet L=0.7U W=10U
Mx2_XMN6_30 OUT x2_n5 GND_DRV GND_LOGIC nfet L=0.7U W=10U
Mx2_XMN6_31 OUT x2_n5 GND_DRV GND_LOGIC nfet L=0.7U W=10U
Mx2_XMN6_32 OUT x2_n5 GND_DRV GND_LOGIC nfet L=0.7U W=10U
Mx2_XMN6_33 OUT x2_n5 GND_DRV GND_LOGIC nfet L=0.7U W=10U
Mx2_XMN6_34 OUT x2_n5 GND_DRV GND_LOGIC nfet L=0.7U W=10U
Mx2_XMN6_35 OUT x2_n5 GND_DRV GND_LOGIC nfet L=0.7U W=10U
Mx2_XMN6_36 OUT x2_n5 GND_DRV GND_LOGIC nfet L=0.7U W=10U
Mx2_XMN6_37 OUT x2_n5 GND_DRV GND_LOGIC nfet L=0.7U W=10U
Mx2_XMN6_38 OUT x2_n5 GND_DRV GND_LOGIC nfet L=0.7U W=10U
Mx2_XMN6_39 OUT x2_n5 GND_DRV GND_LOGIC nfet L=0.7U W=10U
Mx2_XMN6_4 OUT x2_n5 GND_DRV GND_LOGIC nfet L=0.7U W=10U
Mx2_XMN6_40 OUT x2_n5 GND_DRV GND_LOGIC nfet L=0.7U W=10U
Mx2_XMN6_41 OUT x2_n5 GND_DRV GND_LOGIC nfet L=0.7U W=10U
Mx2_XMN6_42 OUT x2_n5 GND_DRV GND_LOGIC nfet L=0.7U W=10U
Mx2_XMN6_43 OUT x2_n5 GND_DRV GND_LOGIC nfet L=0.7U W=10U
Mx2_XMN6_44 OUT x2_n5 GND_DRV GND_LOGIC nfet L=0.7U W=10U
Mx2_XMN6_45 OUT x2_n5 GND_DRV GND_LOGIC nfet L=0.7U W=10U
Mx2_XMN6_46 OUT x2_n5 GND_DRV GND_LOGIC nfet L=0.7U W=10U
Mx2_XMN6_47 OUT x2_n5 GND_DRV GND_LOGIC nfet L=0.7U W=10U
Mx2_XMN6_48 OUT x2_n5 GND_DRV GND_LOGIC nfet L=0.7U W=10U
Mx2_XMN6_49 OUT x2_n5 GND_DRV GND_LOGIC nfet L=0.7U W=10U
Mx2_XMN6_5 OUT x2_n5 GND_DRV GND_LOGIC nfet L=0.7U W=10U
Mx2_XMN6_50 OUT x2_n5 GND_DRV GND_LOGIC nfet L=0.7U W=10U
Mx2_XMN6_51 OUT x2_n5 GND_DRV GND_LOGIC nfet L=0.7U W=10U
Mx2_XMN6_52 OUT x2_n5 GND_DRV GND_LOGIC nfet L=0.7U W=10U
Mx2_XMN6_53 OUT x2_n5 GND_DRV GND_LOGIC nfet L=0.7U W=10U
Mx2_XMN6_54 OUT x2_n5 GND_DRV GND_LOGIC nfet L=0.7U W=10U
Mx2_XMN6_55 OUT x2_n5 GND_DRV GND_LOGIC nfet L=0.7U W=10U
Mx2_XMN6_56 OUT x2_n5 GND_DRV GND_LOGIC nfet L=0.7U W=10U
Mx2_XMN6_57 OUT x2_n5 GND_DRV GND_LOGIC nfet L=0.7U W=10U
Mx2_XMN6_58 OUT x2_n5 GND_DRV GND_LOGIC nfet L=0.7U W=10U
Mx2_XMN6_59 OUT x2_n5 GND_DRV GND_LOGIC nfet L=0.7U W=10U
Mx2_XMN6_6 OUT x2_n5 GND_DRV GND_LOGIC nfet L=0.7U W=10U
Mx2_XMN6_60 OUT x2_n5 GND_DRV GND_LOGIC nfet L=0.7U W=10U
Mx2_XMN6_61 OUT x2_n5 GND_DRV GND_LOGIC nfet L=0.7U W=10U
Mx2_XMN6_62 OUT x2_n5 GND_DRV GND_LOGIC nfet L=0.7U W=10U
Mx2_XMN6_63 OUT x2_n5 GND_DRV GND_LOGIC nfet L=0.7U W=10U
Mx2_XMN6_64 OUT x2_n5 GND_DRV GND_LOGIC nfet L=0.7U W=10U
Mx2_XMN6_65 OUT x2_n5 GND_DRV GND_LOGIC nfet L=0.7U W=10U
Mx2_XMN6_66 OUT x2_n5 GND_DRV GND_LOGIC nfet L=0.7U W=10U
Mx2_XMN6_67 OUT x2_n5 GND_DRV GND_LOGIC nfet L=0.7U W=10U
Mx2_XMN6_68 OUT x2_n5 GND_DRV GND_LOGIC nfet L=0.7U W=10U
Mx2_XMN6_69 OUT x2_n5 GND_DRV GND_LOGIC nfet L=0.7U W=10U
Mx2_XMN6_7 OUT x2_n5 GND_DRV GND_LOGIC nfet L=0.7U W=10U
Mx2_XMN6_70 OUT x2_n5 GND_DRV GND_LOGIC nfet L=0.7U W=10U
Mx2_XMN6_71 OUT x2_n5 GND_DRV GND_LOGIC nfet L=0.7U W=10U
Mx2_XMN6_72 OUT x2_n5 GND_DRV GND_LOGIC nfet L=0.7U W=10U
Mx2_XMN6_73 OUT x2_n5 GND_DRV GND_LOGIC nfet L=0.7U W=10U
Mx2_XMN6_74 OUT x2_n5 GND_DRV GND_LOGIC nfet L=0.7U W=10U
Mx2_XMN6_75 OUT x2_n5 GND_DRV GND_LOGIC nfet L=0.7U W=10U
Mx2_XMN6_76 OUT x2_n5 GND_DRV GND_LOGIC nfet L=0.7U W=10U
Mx2_XMN6_77 OUT x2_n5 GND_DRV GND_LOGIC nfet L=0.7U W=10U
Mx2_XMN6_78 OUT x2_n5 GND_DRV GND_LOGIC nfet L=0.7U W=10U
Mx2_XMN6_79 OUT x2_n5 GND_DRV GND_LOGIC nfet L=0.7U W=10U
Mx2_XMN6_8 OUT x2_n5 GND_DRV GND_LOGIC nfet L=0.7U W=10U
Mx2_XMN6_80 OUT x2_n5 GND_DRV GND_LOGIC nfet L=0.7U W=10U
Mx2_XMN6_81 OUT x2_n5 GND_DRV GND_LOGIC nfet L=0.7U W=10U
Mx2_XMN6_82 OUT x2_n5 GND_DRV GND_LOGIC nfet L=0.7U W=10U
Mx2_XMN6_83 OUT x2_n5 GND_DRV GND_LOGIC nfet L=0.7U W=10U
Mx2_XMN6_84 OUT x2_n5 GND_DRV GND_LOGIC nfet L=0.7U W=10U
Mx2_XMN6_85 OUT x2_n5 GND_DRV GND_LOGIC nfet L=0.7U W=10U
Mx2_XMN6_86 OUT x2_n5 GND_DRV GND_LOGIC nfet L=0.7U W=10U
Mx2_XMN6_87 OUT x2_n5 GND_DRV GND_LOGIC nfet L=0.7U W=10U
Mx2_XMN6_88 OUT x2_n5 GND_DRV GND_LOGIC nfet L=0.7U W=10U
Mx2_XMN6_89 OUT x2_n5 GND_DRV GND_LOGIC nfet L=0.7U W=10U
Mx2_XMN6_9 OUT x2_n5 GND_DRV GND_LOGIC nfet L=0.7U W=10U
Mx2_XMN6_90 OUT x2_n5 GND_DRV GND_LOGIC nfet L=0.7U W=10U
Mx2_XMN6_91 OUT x2_n5 GND_DRV GND_LOGIC nfet L=0.7U W=10U
Mx2_XMN6_92 OUT x2_n5 GND_DRV GND_LOGIC nfet L=0.7U W=10U
Mx2_XMN6_93 OUT x2_n5 GND_DRV GND_LOGIC nfet L=0.7U W=10U
Mx2_XMN6_94 OUT x2_n5 GND_DRV GND_LOGIC nfet L=0.7U W=10U
Mx2_XMN6_95 OUT x2_n5 GND_DRV GND_LOGIC nfet L=0.7U W=10U
Mx2_XMN6_96 OUT x2_n5 GND_DRV GND_LOGIC nfet L=0.7U W=10U
Mx2_XMN6_97 OUT x2_n5 GND_DRV GND_LOGIC nfet L=0.7U W=10U
Mx2_XMN6_98 OUT x2_n5 GND_DRV GND_LOGIC nfet L=0.7U W=10U
Mx2_XMN6_99 OUT x2_n5 GND_DRV GND_LOGIC nfet L=0.7U W=10U
Mx2_XMP1_0 x2_n1 IN_DRV VDD_DRV VDD_DRV pfet L=0.55U W=4.4U
Mx2_XMP2_0 x2_n2 x2_n1 VDD_DRV VDD_DRV pfet L=0.55U W=18U
Mx2_XMP3_0 x2_n3 x2_n2 VDD_DRV VDD_DRV pfet L=0.55U W=73U
Mx2_XMP4_0 x2_n4 x2_n3 VDD_DRV VDD_DRV pfet L=0.55U W=10U
Mx2_XMP4_1 x2_n4 x2_n3 VDD_DRV VDD_DRV pfet L=0.55U W=10U
Mx2_XMP4_10 x2_n4 x2_n3 VDD_DRV VDD_DRV pfet L=0.55U W=10U
Mx2_XMP4_11 x2_n4 x2_n3 VDD_DRV VDD_DRV pfet L=0.55U W=10U
Mx2_XMP4_12 x2_n4 x2_n3 VDD_DRV VDD_DRV pfet L=0.55U W=10U
Mx2_XMP4_13 x2_n4 x2_n3 VDD_DRV VDD_DRV pfet L=0.55U W=10U
Mx2_XMP4_14 x2_n4 x2_n3 VDD_DRV VDD_DRV pfet L=0.55U W=10U
Mx2_XMP4_15 x2_n4 x2_n3 VDD_DRV VDD_DRV pfet L=0.55U W=10U
Mx2_XMP4_16 x2_n4 x2_n3 VDD_DRV VDD_DRV pfet L=0.55U W=10U
Mx2_XMP4_17 x2_n4 x2_n3 VDD_DRV VDD_DRV pfet L=0.55U W=10U
Mx2_XMP4_18 x2_n4 x2_n3 VDD_DRV VDD_DRV pfet L=0.55U W=10U
Mx2_XMP4_19 x2_n4 x2_n3 VDD_DRV VDD_DRV pfet L=0.55U W=10U
Mx2_XMP4_2 x2_n4 x2_n3 VDD_DRV VDD_DRV pfet L=0.55U W=10U
Mx2_XMP4_20 x2_n4 x2_n3 VDD_DRV VDD_DRV pfet L=0.55U W=10U
Mx2_XMP4_21 x2_n4 x2_n3 VDD_DRV VDD_DRV pfet L=0.55U W=10U
Mx2_XMP4_22 x2_n4 x2_n3 VDD_DRV VDD_DRV pfet L=0.55U W=10U
Mx2_XMP4_23 x2_n4 x2_n3 VDD_DRV VDD_DRV pfet L=0.55U W=10U
Mx2_XMP4_24 x2_n4 x2_n3 VDD_DRV VDD_DRV pfet L=0.55U W=10U
Mx2_XMP4_25 x2_n4 x2_n3 VDD_DRV VDD_DRV pfet L=0.55U W=10U
Mx2_XMP4_26 x2_n4 x2_n3 VDD_DRV VDD_DRV pfet L=0.55U W=10U
Mx2_XMP4_27 x2_n4 x2_n3 VDD_DRV VDD_DRV pfet L=0.55U W=10U
Mx2_XMP4_28 x2_n4 x2_n3 VDD_DRV VDD_DRV pfet L=0.55U W=10U
Mx2_XMP4_29 x2_n4 x2_n3 VDD_DRV VDD_DRV pfet L=0.55U W=10U
Mx2_XMP4_3 x2_n4 x2_n3 VDD_DRV VDD_DRV pfet L=0.55U W=10U
Mx2_XMP4_4 x2_n4 x2_n3 VDD_DRV VDD_DRV pfet L=0.55U W=10U
Mx2_XMP4_5 x2_n4 x2_n3 VDD_DRV VDD_DRV pfet L=0.55U W=10U
Mx2_XMP4_6 x2_n4 x2_n3 VDD_DRV VDD_DRV pfet L=0.55U W=10U
Mx2_XMP4_7 x2_n4 x2_n3 VDD_DRV VDD_DRV pfet L=0.55U W=10U
Mx2_XMP4_8 x2_n4 x2_n3 VDD_DRV VDD_DRV pfet L=0.55U W=10U
Mx2_XMP4_9 x2_n4 x2_n3 VDD_DRV VDD_DRV pfet L=0.55U W=10U
Mx2_XMP5_0 x2_n5 x2_n4 VDD_DRV VDD_DRV pfet L=0.55U W=10U
Mx2_XMP5_1 x2_n5 x2_n4 VDD_DRV VDD_DRV pfet L=0.55U W=10U
Mx2_XMP5_10 x2_n5 x2_n4 VDD_DRV VDD_DRV pfet L=0.55U W=10U
Mx2_XMP5_100 x2_n5 x2_n4 VDD_DRV VDD_DRV pfet L=0.55U W=10U
Mx2_XMP5_101 x2_n5 x2_n4 VDD_DRV VDD_DRV pfet L=0.55U W=10U
Mx2_XMP5_102 x2_n5 x2_n4 VDD_DRV VDD_DRV pfet L=0.55U W=10U
Mx2_XMP5_103 x2_n5 x2_n4 VDD_DRV VDD_DRV pfet L=0.55U W=10U
Mx2_XMP5_104 x2_n5 x2_n4 VDD_DRV VDD_DRV pfet L=0.55U W=10U
Mx2_XMP5_105 x2_n5 x2_n4 VDD_DRV VDD_DRV pfet L=0.55U W=10U
Mx2_XMP5_106 x2_n5 x2_n4 VDD_DRV VDD_DRV pfet L=0.55U W=10U
Mx2_XMP5_107 x2_n5 x2_n4 VDD_DRV VDD_DRV pfet L=0.55U W=10U
Mx2_XMP5_108 x2_n5 x2_n4 VDD_DRV VDD_DRV pfet L=0.55U W=10U
Mx2_XMP5_109 x2_n5 x2_n4 VDD_DRV VDD_DRV pfet L=0.55U W=10U
Mx2_XMP5_11 x2_n5 x2_n4 VDD_DRV VDD_DRV pfet L=0.55U W=10U
Mx2_XMP5_110 x2_n5 x2_n4 VDD_DRV VDD_DRV pfet L=0.55U W=10U
Mx2_XMP5_111 x2_n5 x2_n4 VDD_DRV VDD_DRV pfet L=0.55U W=10U
Mx2_XMP5_112 x2_n5 x2_n4 VDD_DRV VDD_DRV pfet L=0.55U W=10U
Mx2_XMP5_113 x2_n5 x2_n4 VDD_DRV VDD_DRV pfet L=0.55U W=10U
Mx2_XMP5_114 x2_n5 x2_n4 VDD_DRV VDD_DRV pfet L=0.55U W=10U
Mx2_XMP5_115 x2_n5 x2_n4 VDD_DRV VDD_DRV pfet L=0.55U W=10U
Mx2_XMP5_116 x2_n5 x2_n4 VDD_DRV VDD_DRV pfet L=0.55U W=10U
Mx2_XMP5_117 x2_n5 x2_n4 VDD_DRV VDD_DRV pfet L=0.55U W=10U
Mx2_XMP5_118 x2_n5 x2_n4 VDD_DRV VDD_DRV pfet L=0.55U W=10U
Mx2_XMP5_119 x2_n5 x2_n4 VDD_DRV VDD_DRV pfet L=0.55U W=10U
Mx2_XMP5_12 x2_n5 x2_n4 VDD_DRV VDD_DRV pfet L=0.55U W=10U
Mx2_XMP5_120 x2_n5 x2_n4 VDD_DRV VDD_DRV pfet L=0.55U W=10U
Mx2_XMP5_121 x2_n5 x2_n4 VDD_DRV VDD_DRV pfet L=0.55U W=10U
Mx2_XMP5_13 x2_n5 x2_n4 VDD_DRV VDD_DRV pfet L=0.55U W=10U
Mx2_XMP5_14 x2_n5 x2_n4 VDD_DRV VDD_DRV pfet L=0.55U W=10U
Mx2_XMP5_15 x2_n5 x2_n4 VDD_DRV VDD_DRV pfet L=0.55U W=10U
Mx2_XMP5_16 x2_n5 x2_n4 VDD_DRV VDD_DRV pfet L=0.55U W=10U
Mx2_XMP5_17 x2_n5 x2_n4 VDD_DRV VDD_DRV pfet L=0.55U W=10U
Mx2_XMP5_18 x2_n5 x2_n4 VDD_DRV VDD_DRV pfet L=0.55U W=10U
Mx2_XMP5_19 x2_n5 x2_n4 VDD_DRV VDD_DRV pfet L=0.55U W=10U
Mx2_XMP5_2 x2_n5 x2_n4 VDD_DRV VDD_DRV pfet L=0.55U W=10U
Mx2_XMP5_20 x2_n5 x2_n4 VDD_DRV VDD_DRV pfet L=0.55U W=10U
Mx2_XMP5_21 x2_n5 x2_n4 VDD_DRV VDD_DRV pfet L=0.55U W=10U
Mx2_XMP5_22 x2_n5 x2_n4 VDD_DRV VDD_DRV pfet L=0.55U W=10U
Mx2_XMP5_23 x2_n5 x2_n4 VDD_DRV VDD_DRV pfet L=0.55U W=10U
Mx2_XMP5_24 x2_n5 x2_n4 VDD_DRV VDD_DRV pfet L=0.55U W=10U
Mx2_XMP5_25 x2_n5 x2_n4 VDD_DRV VDD_DRV pfet L=0.55U W=10U
Mx2_XMP5_26 x2_n5 x2_n4 VDD_DRV VDD_DRV pfet L=0.55U W=10U
Mx2_XMP5_27 x2_n5 x2_n4 VDD_DRV VDD_DRV pfet L=0.55U W=10U
Mx2_XMP5_28 x2_n5 x2_n4 VDD_DRV VDD_DRV pfet L=0.55U W=10U
Mx2_XMP5_29 x2_n5 x2_n4 VDD_DRV VDD_DRV pfet L=0.55U W=10U
Mx2_XMP5_3 x2_n5 x2_n4 VDD_DRV VDD_DRV pfet L=0.55U W=10U
Mx2_XMP5_30 x2_n5 x2_n4 VDD_DRV VDD_DRV pfet L=0.55U W=10U
Mx2_XMP5_31 x2_n5 x2_n4 VDD_DRV VDD_DRV pfet L=0.55U W=10U
Mx2_XMP5_32 x2_n5 x2_n4 VDD_DRV VDD_DRV pfet L=0.55U W=10U
Mx2_XMP5_33 x2_n5 x2_n4 VDD_DRV VDD_DRV pfet L=0.55U W=10U
Mx2_XMP5_34 x2_n5 x2_n4 VDD_DRV VDD_DRV pfet L=0.55U W=10U
Mx2_XMP5_35 x2_n5 x2_n4 VDD_DRV VDD_DRV pfet L=0.55U W=10U
Mx2_XMP5_36 x2_n5 x2_n4 VDD_DRV VDD_DRV pfet L=0.55U W=10U
Mx2_XMP5_37 x2_n5 x2_n4 VDD_DRV VDD_DRV pfet L=0.55U W=10U
Mx2_XMP5_38 x2_n5 x2_n4 VDD_DRV VDD_DRV pfet L=0.55U W=10U
Mx2_XMP5_39 x2_n5 x2_n4 VDD_DRV VDD_DRV pfet L=0.55U W=10U
Mx2_XMP5_4 x2_n5 x2_n4 VDD_DRV VDD_DRV pfet L=0.55U W=10U
Mx2_XMP5_40 x2_n5 x2_n4 VDD_DRV VDD_DRV pfet L=0.55U W=10U
Mx2_XMP5_41 x2_n5 x2_n4 VDD_DRV VDD_DRV pfet L=0.55U W=10U
Mx2_XMP5_42 x2_n5 x2_n4 VDD_DRV VDD_DRV pfet L=0.55U W=10U
Mx2_XMP5_43 x2_n5 x2_n4 VDD_DRV VDD_DRV pfet L=0.55U W=10U
Mx2_XMP5_44 x2_n5 x2_n4 VDD_DRV VDD_DRV pfet L=0.55U W=10U
Mx2_XMP5_45 x2_n5 x2_n4 VDD_DRV VDD_DRV pfet L=0.55U W=10U
Mx2_XMP5_46 x2_n5 x2_n4 VDD_DRV VDD_DRV pfet L=0.55U W=10U
Mx2_XMP5_47 x2_n5 x2_n4 VDD_DRV VDD_DRV pfet L=0.55U W=10U
Mx2_XMP5_48 x2_n5 x2_n4 VDD_DRV VDD_DRV pfet L=0.55U W=10U
Mx2_XMP5_49 x2_n5 x2_n4 VDD_DRV VDD_DRV pfet L=0.55U W=10U
Mx2_XMP5_5 x2_n5 x2_n4 VDD_DRV VDD_DRV pfet L=0.55U W=10U
Mx2_XMP5_50 x2_n5 x2_n4 VDD_DRV VDD_DRV pfet L=0.55U W=10U
Mx2_XMP5_51 x2_n5 x2_n4 VDD_DRV VDD_DRV pfet L=0.55U W=10U
Mx2_XMP5_52 x2_n5 x2_n4 VDD_DRV VDD_DRV pfet L=0.55U W=10U
Mx2_XMP5_53 x2_n5 x2_n4 VDD_DRV VDD_DRV pfet L=0.55U W=10U
Mx2_XMP5_54 x2_n5 x2_n4 VDD_DRV VDD_DRV pfet L=0.55U W=10U
Mx2_XMP5_55 x2_n5 x2_n4 VDD_DRV VDD_DRV pfet L=0.55U W=10U
Mx2_XMP5_56 x2_n5 x2_n4 VDD_DRV VDD_DRV pfet L=0.55U W=10U
Mx2_XMP5_57 x2_n5 x2_n4 VDD_DRV VDD_DRV pfet L=0.55U W=10U
Mx2_XMP5_58 x2_n5 x2_n4 VDD_DRV VDD_DRV pfet L=0.55U W=10U
Mx2_XMP5_59 x2_n5 x2_n4 VDD_DRV VDD_DRV pfet L=0.55U W=10U
Mx2_XMP5_6 x2_n5 x2_n4 VDD_DRV VDD_DRV pfet L=0.55U W=10U
Mx2_XMP5_60 x2_n5 x2_n4 VDD_DRV VDD_DRV pfet L=0.55U W=10U
Mx2_XMP5_61 x2_n5 x2_n4 VDD_DRV VDD_DRV pfet L=0.55U W=10U
Mx2_XMP5_62 x2_n5 x2_n4 VDD_DRV VDD_DRV pfet L=0.55U W=10U
Mx2_XMP5_63 x2_n5 x2_n4 VDD_DRV VDD_DRV pfet L=0.55U W=10U
Mx2_XMP5_64 x2_n5 x2_n4 VDD_DRV VDD_DRV pfet L=0.55U W=10U
Mx2_XMP5_65 x2_n5 x2_n4 VDD_DRV VDD_DRV pfet L=0.55U W=10U
Mx2_XMP5_66 x2_n5 x2_n4 VDD_DRV VDD_DRV pfet L=0.55U W=10U
Mx2_XMP5_67 x2_n5 x2_n4 VDD_DRV VDD_DRV pfet L=0.55U W=10U
Mx2_XMP5_68 x2_n5 x2_n4 VDD_DRV VDD_DRV pfet L=0.55U W=10U
Mx2_XMP5_69 x2_n5 x2_n4 VDD_DRV VDD_DRV pfet L=0.55U W=10U
Mx2_XMP5_7 x2_n5 x2_n4 VDD_DRV VDD_DRV pfet L=0.55U W=10U
Mx2_XMP5_70 x2_n5 x2_n4 VDD_DRV VDD_DRV pfet L=0.55U W=10U
Mx2_XMP5_71 x2_n5 x2_n4 VDD_DRV VDD_DRV pfet L=0.55U W=10U
Mx2_XMP5_72 x2_n5 x2_n4 VDD_DRV VDD_DRV pfet L=0.55U W=10U
Mx2_XMP5_73 x2_n5 x2_n4 VDD_DRV VDD_DRV pfet L=0.55U W=10U
Mx2_XMP5_74 x2_n5 x2_n4 VDD_DRV VDD_DRV pfet L=0.55U W=10U
Mx2_XMP5_75 x2_n5 x2_n4 VDD_DRV VDD_DRV pfet L=0.55U W=10U
Mx2_XMP5_76 x2_n5 x2_n4 VDD_DRV VDD_DRV pfet L=0.55U W=10U
Mx2_XMP5_77 x2_n5 x2_n4 VDD_DRV VDD_DRV pfet L=0.55U W=10U
Mx2_XMP5_78 x2_n5 x2_n4 VDD_DRV VDD_DRV pfet L=0.55U W=10U
Mx2_XMP5_79 x2_n5 x2_n4 VDD_DRV VDD_DRV pfet L=0.55U W=10U
Mx2_XMP5_8 x2_n5 x2_n4 VDD_DRV VDD_DRV pfet L=0.55U W=10U
Mx2_XMP5_80 x2_n5 x2_n4 VDD_DRV VDD_DRV pfet L=0.55U W=10U
Mx2_XMP5_81 x2_n5 x2_n4 VDD_DRV VDD_DRV pfet L=0.55U W=10U
Mx2_XMP5_82 x2_n5 x2_n4 VDD_DRV VDD_DRV pfet L=0.55U W=10U
Mx2_XMP5_83 x2_n5 x2_n4 VDD_DRV VDD_DRV pfet L=0.55U W=10U
Mx2_XMP5_84 x2_n5 x2_n4 VDD_DRV VDD_DRV pfet L=0.55U W=10U
Mx2_XMP5_85 x2_n5 x2_n4 VDD_DRV VDD_DRV pfet L=0.55U W=10U
Mx2_XMP5_86 x2_n5 x2_n4 VDD_DRV VDD_DRV pfet L=0.55U W=10U
Mx2_XMP5_87 x2_n5 x2_n4 VDD_DRV VDD_DRV pfet L=0.55U W=10U
Mx2_XMP5_88 x2_n5 x2_n4 VDD_DRV VDD_DRV pfet L=0.55U W=10U
Mx2_XMP5_89 x2_n5 x2_n4 VDD_DRV VDD_DRV pfet L=0.55U W=10U
Mx2_XMP5_9 x2_n5 x2_n4 VDD_DRV VDD_DRV pfet L=0.55U W=10U
Mx2_XMP5_90 x2_n5 x2_n4 VDD_DRV VDD_DRV pfet L=0.55U W=10U
Mx2_XMP5_91 x2_n5 x2_n4 VDD_DRV VDD_DRV pfet L=0.55U W=10U
Mx2_XMP5_92 x2_n5 x2_n4 VDD_DRV VDD_DRV pfet L=0.55U W=10U
Mx2_XMP5_93 x2_n5 x2_n4 VDD_DRV VDD_DRV pfet L=0.55U W=10U
Mx2_XMP5_94 x2_n5 x2_n4 VDD_DRV VDD_DRV pfet L=0.55U W=10U
Mx2_XMP5_95 x2_n5 x2_n4 VDD_DRV VDD_DRV pfet L=0.55U W=10U
Mx2_XMP5_96 x2_n5 x2_n4 VDD_DRV VDD_DRV pfet L=0.55U W=10U
Mx2_XMP5_97 x2_n5 x2_n4 VDD_DRV VDD_DRV pfet L=0.55U W=10U
Mx2_XMP5_98 x2_n5 x2_n4 VDD_DRV VDD_DRV pfet L=0.55U W=10U
Mx2_XMP5_99 x2_n5 x2_n4 VDD_DRV VDD_DRV pfet L=0.55U W=10U
Mx2_XMP6_0 OUT x2_n5 VDD_DRV VDD_DRV pfet L=0.55U W=10U
Mx2_XMP6_1 OUT x2_n5 VDD_DRV VDD_DRV pfet L=0.55U W=10U
Mx2_XMP6_10 OUT x2_n5 VDD_DRV VDD_DRV pfet L=0.55U W=10U
Mx2_XMP6_100 OUT x2_n5 VDD_DRV VDD_DRV pfet L=0.55U W=10U
Mx2_XMP6_101 OUT x2_n5 VDD_DRV VDD_DRV pfet L=0.55U W=10U
Mx2_XMP6_102 OUT x2_n5 VDD_DRV VDD_DRV pfet L=0.55U W=10U
Mx2_XMP6_103 OUT x2_n5 VDD_DRV VDD_DRV pfet L=0.55U W=10U
Mx2_XMP6_104 OUT x2_n5 VDD_DRV VDD_DRV pfet L=0.55U W=10U
Mx2_XMP6_105 OUT x2_n5 VDD_DRV VDD_DRV pfet L=0.55U W=10U
Mx2_XMP6_106 OUT x2_n5 VDD_DRV VDD_DRV pfet L=0.55U W=10U
Mx2_XMP6_107 OUT x2_n5 VDD_DRV VDD_DRV pfet L=0.55U W=10U
Mx2_XMP6_108 OUT x2_n5 VDD_DRV VDD_DRV pfet L=0.55U W=10U
Mx2_XMP6_109 OUT x2_n5 VDD_DRV VDD_DRV pfet L=0.55U W=10U
Mx2_XMP6_11 OUT x2_n5 VDD_DRV VDD_DRV pfet L=0.55U W=10U
Mx2_XMP6_110 OUT x2_n5 VDD_DRV VDD_DRV pfet L=0.55U W=10U
Mx2_XMP6_111 OUT x2_n5 VDD_DRV VDD_DRV pfet L=0.55U W=10U
Mx2_XMP6_112 OUT x2_n5 VDD_DRV VDD_DRV pfet L=0.55U W=10U
Mx2_XMP6_113 OUT x2_n5 VDD_DRV VDD_DRV pfet L=0.55U W=10U
Mx2_XMP6_114 OUT x2_n5 VDD_DRV VDD_DRV pfet L=0.55U W=10U
Mx2_XMP6_115 OUT x2_n5 VDD_DRV VDD_DRV pfet L=0.55U W=10U
Mx2_XMP6_116 OUT x2_n5 VDD_DRV VDD_DRV pfet L=0.55U W=10U
Mx2_XMP6_117 OUT x2_n5 VDD_DRV VDD_DRV pfet L=0.55U W=10U
Mx2_XMP6_118 OUT x2_n5 VDD_DRV VDD_DRV pfet L=0.55U W=10U
Mx2_XMP6_119 OUT x2_n5 VDD_DRV VDD_DRV pfet L=0.55U W=10U
Mx2_XMP6_12 OUT x2_n5 VDD_DRV VDD_DRV pfet L=0.55U W=10U
Mx2_XMP6_120 OUT x2_n5 VDD_DRV VDD_DRV pfet L=0.55U W=10U
Mx2_XMP6_121 OUT x2_n5 VDD_DRV VDD_DRV pfet L=0.55U W=10U
Mx2_XMP6_122 OUT x2_n5 VDD_DRV VDD_DRV pfet L=0.55U W=10U
Mx2_XMP6_123 OUT x2_n5 VDD_DRV VDD_DRV pfet L=0.55U W=10U
Mx2_XMP6_124 OUT x2_n5 VDD_DRV VDD_DRV pfet L=0.55U W=10U
Mx2_XMP6_125 OUT x2_n5 VDD_DRV VDD_DRV pfet L=0.55U W=10U
Mx2_XMP6_126 OUT x2_n5 VDD_DRV VDD_DRV pfet L=0.55U W=10U
Mx2_XMP6_127 OUT x2_n5 VDD_DRV VDD_DRV pfet L=0.55U W=10U
Mx2_XMP6_128 OUT x2_n5 VDD_DRV VDD_DRV pfet L=0.55U W=10U
Mx2_XMP6_129 OUT x2_n5 VDD_DRV VDD_DRV pfet L=0.55U W=10U
Mx2_XMP6_13 OUT x2_n5 VDD_DRV VDD_DRV pfet L=0.55U W=10U
Mx2_XMP6_130 OUT x2_n5 VDD_DRV VDD_DRV pfet L=0.55U W=10U
Mx2_XMP6_131 OUT x2_n5 VDD_DRV VDD_DRV pfet L=0.55U W=10U
Mx2_XMP6_132 OUT x2_n5 VDD_DRV VDD_DRV pfet L=0.55U W=10U
Mx2_XMP6_133 OUT x2_n5 VDD_DRV VDD_DRV pfet L=0.55U W=10U
Mx2_XMP6_134 OUT x2_n5 VDD_DRV VDD_DRV pfet L=0.55U W=10U
Mx2_XMP6_135 OUT x2_n5 VDD_DRV VDD_DRV pfet L=0.55U W=10U
Mx2_XMP6_136 OUT x2_n5 VDD_DRV VDD_DRV pfet L=0.55U W=10U
Mx2_XMP6_137 OUT x2_n5 VDD_DRV VDD_DRV pfet L=0.55U W=10U
Mx2_XMP6_138 OUT x2_n5 VDD_DRV VDD_DRV pfet L=0.55U W=10U
Mx2_XMP6_139 OUT x2_n5 VDD_DRV VDD_DRV pfet L=0.55U W=10U
Mx2_XMP6_14 OUT x2_n5 VDD_DRV VDD_DRV pfet L=0.55U W=10U
Mx2_XMP6_140 OUT x2_n5 VDD_DRV VDD_DRV pfet L=0.55U W=10U
Mx2_XMP6_141 OUT x2_n5 VDD_DRV VDD_DRV pfet L=0.55U W=10U
Mx2_XMP6_142 OUT x2_n5 VDD_DRV VDD_DRV pfet L=0.55U W=10U
Mx2_XMP6_143 OUT x2_n5 VDD_DRV VDD_DRV pfet L=0.55U W=10U
Mx2_XMP6_144 OUT x2_n5 VDD_DRV VDD_DRV pfet L=0.55U W=10U
Mx2_XMP6_145 OUT x2_n5 VDD_DRV VDD_DRV pfet L=0.55U W=10U
Mx2_XMP6_146 OUT x2_n5 VDD_DRV VDD_DRV pfet L=0.55U W=10U
Mx2_XMP6_147 OUT x2_n5 VDD_DRV VDD_DRV pfet L=0.55U W=10U
Mx2_XMP6_148 OUT x2_n5 VDD_DRV VDD_DRV pfet L=0.55U W=10U
Mx2_XMP6_149 OUT x2_n5 VDD_DRV VDD_DRV pfet L=0.55U W=10U
Mx2_XMP6_15 OUT x2_n5 VDD_DRV VDD_DRV pfet L=0.55U W=10U
Mx2_XMP6_150 OUT x2_n5 VDD_DRV VDD_DRV pfet L=0.55U W=10U
Mx2_XMP6_151 OUT x2_n5 VDD_DRV VDD_DRV pfet L=0.55U W=10U
Mx2_XMP6_152 OUT x2_n5 VDD_DRV VDD_DRV pfet L=0.55U W=10U
Mx2_XMP6_153 OUT x2_n5 VDD_DRV VDD_DRV pfet L=0.55U W=10U
Mx2_XMP6_154 OUT x2_n5 VDD_DRV VDD_DRV pfet L=0.55U W=10U
Mx2_XMP6_155 OUT x2_n5 VDD_DRV VDD_DRV pfet L=0.55U W=10U
Mx2_XMP6_156 OUT x2_n5 VDD_DRV VDD_DRV pfet L=0.55U W=10U
Mx2_XMP6_157 OUT x2_n5 VDD_DRV VDD_DRV pfet L=0.55U W=10U
Mx2_XMP6_158 OUT x2_n5 VDD_DRV VDD_DRV pfet L=0.55U W=10U
Mx2_XMP6_159 OUT x2_n5 VDD_DRV VDD_DRV pfet L=0.55U W=10U
Mx2_XMP6_16 OUT x2_n5 VDD_DRV VDD_DRV pfet L=0.55U W=10U
Mx2_XMP6_160 OUT x2_n5 VDD_DRV VDD_DRV pfet L=0.55U W=10U
Mx2_XMP6_161 OUT x2_n5 VDD_DRV VDD_DRV pfet L=0.55U W=10U
Mx2_XMP6_162 OUT x2_n5 VDD_DRV VDD_DRV pfet L=0.55U W=10U
Mx2_XMP6_163 OUT x2_n5 VDD_DRV VDD_DRV pfet L=0.55U W=10U
Mx2_XMP6_164 OUT x2_n5 VDD_DRV VDD_DRV pfet L=0.55U W=10U
Mx2_XMP6_165 OUT x2_n5 VDD_DRV VDD_DRV pfet L=0.55U W=10U
Mx2_XMP6_166 OUT x2_n5 VDD_DRV VDD_DRV pfet L=0.55U W=10U
Mx2_XMP6_167 OUT x2_n5 VDD_DRV VDD_DRV pfet L=0.55U W=10U
Mx2_XMP6_168 OUT x2_n5 VDD_DRV VDD_DRV pfet L=0.55U W=10U
Mx2_XMP6_169 OUT x2_n5 VDD_DRV VDD_DRV pfet L=0.55U W=10U
Mx2_XMP6_17 OUT x2_n5 VDD_DRV VDD_DRV pfet L=0.55U W=10U
Mx2_XMP6_170 OUT x2_n5 VDD_DRV VDD_DRV pfet L=0.55U W=10U
Mx2_XMP6_171 OUT x2_n5 VDD_DRV VDD_DRV pfet L=0.55U W=10U
Mx2_XMP6_172 OUT x2_n5 VDD_DRV VDD_DRV pfet L=0.55U W=10U
Mx2_XMP6_173 OUT x2_n5 VDD_DRV VDD_DRV pfet L=0.55U W=10U
Mx2_XMP6_174 OUT x2_n5 VDD_DRV VDD_DRV pfet L=0.55U W=10U
Mx2_XMP6_175 OUT x2_n5 VDD_DRV VDD_DRV pfet L=0.55U W=10U
Mx2_XMP6_176 OUT x2_n5 VDD_DRV VDD_DRV pfet L=0.55U W=10U
Mx2_XMP6_177 OUT x2_n5 VDD_DRV VDD_DRV pfet L=0.55U W=10U
Mx2_XMP6_178 OUT x2_n5 VDD_DRV VDD_DRV pfet L=0.55U W=10U
Mx2_XMP6_179 OUT x2_n5 VDD_DRV VDD_DRV pfet L=0.55U W=10U
Mx2_XMP6_18 OUT x2_n5 VDD_DRV VDD_DRV pfet L=0.55U W=10U
Mx2_XMP6_180 OUT x2_n5 VDD_DRV VDD_DRV pfet L=0.55U W=10U
Mx2_XMP6_181 OUT x2_n5 VDD_DRV VDD_DRV pfet L=0.55U W=10U
Mx2_XMP6_182 OUT x2_n5 VDD_DRV VDD_DRV pfet L=0.55U W=10U
Mx2_XMP6_183 OUT x2_n5 VDD_DRV VDD_DRV pfet L=0.55U W=10U
Mx2_XMP6_184 OUT x2_n5 VDD_DRV VDD_DRV pfet L=0.55U W=10U
Mx2_XMP6_185 OUT x2_n5 VDD_DRV VDD_DRV pfet L=0.55U W=10U
Mx2_XMP6_186 OUT x2_n5 VDD_DRV VDD_DRV pfet L=0.55U W=10U
Mx2_XMP6_187 OUT x2_n5 VDD_DRV VDD_DRV pfet L=0.55U W=10U
Mx2_XMP6_188 OUT x2_n5 VDD_DRV VDD_DRV pfet L=0.55U W=10U
Mx2_XMP6_189 OUT x2_n5 VDD_DRV VDD_DRV pfet L=0.55U W=10U
Mx2_XMP6_19 OUT x2_n5 VDD_DRV VDD_DRV pfet L=0.55U W=10U
Mx2_XMP6_190 OUT x2_n5 VDD_DRV VDD_DRV pfet L=0.55U W=10U
Mx2_XMP6_191 OUT x2_n5 VDD_DRV VDD_DRV pfet L=0.55U W=10U
Mx2_XMP6_192 OUT x2_n5 VDD_DRV VDD_DRV pfet L=0.55U W=10U
Mx2_XMP6_193 OUT x2_n5 VDD_DRV VDD_DRV pfet L=0.55U W=10U
Mx2_XMP6_194 OUT x2_n5 VDD_DRV VDD_DRV pfet L=0.55U W=10U
Mx2_XMP6_195 OUT x2_n5 VDD_DRV VDD_DRV pfet L=0.55U W=10U
Mx2_XMP6_196 OUT x2_n5 VDD_DRV VDD_DRV pfet L=0.55U W=10U
Mx2_XMP6_197 OUT x2_n5 VDD_DRV VDD_DRV pfet L=0.55U W=10U
Mx2_XMP6_198 OUT x2_n5 VDD_DRV VDD_DRV pfet L=0.55U W=10U
Mx2_XMP6_199 OUT x2_n5 VDD_DRV VDD_DRV pfet L=0.55U W=10U
Mx2_XMP6_2 OUT x2_n5 VDD_DRV VDD_DRV pfet L=0.55U W=10U
Mx2_XMP6_20 OUT x2_n5 VDD_DRV VDD_DRV pfet L=0.55U W=10U
Mx2_XMP6_200 OUT x2_n5 VDD_DRV VDD_DRV pfet L=0.55U W=10U
Mx2_XMP6_201 OUT x2_n5 VDD_DRV VDD_DRV pfet L=0.55U W=10U
Mx2_XMP6_202 OUT x2_n5 VDD_DRV VDD_DRV pfet L=0.55U W=10U
Mx2_XMP6_203 OUT x2_n5 VDD_DRV VDD_DRV pfet L=0.55U W=10U
Mx2_XMP6_204 OUT x2_n5 VDD_DRV VDD_DRV pfet L=0.55U W=10U
Mx2_XMP6_205 OUT x2_n5 VDD_DRV VDD_DRV pfet L=0.55U W=10U
Mx2_XMP6_206 OUT x2_n5 VDD_DRV VDD_DRV pfet L=0.55U W=10U
Mx2_XMP6_207 OUT x2_n5 VDD_DRV VDD_DRV pfet L=0.55U W=10U
Mx2_XMP6_208 OUT x2_n5 VDD_DRV VDD_DRV pfet L=0.55U W=10U
Mx2_XMP6_209 OUT x2_n5 VDD_DRV VDD_DRV pfet L=0.55U W=10U
Mx2_XMP6_21 OUT x2_n5 VDD_DRV VDD_DRV pfet L=0.55U W=10U
Mx2_XMP6_210 OUT x2_n5 VDD_DRV VDD_DRV pfet L=0.55U W=10U
Mx2_XMP6_211 OUT x2_n5 VDD_DRV VDD_DRV pfet L=0.55U W=10U
Mx2_XMP6_212 OUT x2_n5 VDD_DRV VDD_DRV pfet L=0.55U W=10U
Mx2_XMP6_213 OUT x2_n5 VDD_DRV VDD_DRV pfet L=0.55U W=10U
Mx2_XMP6_214 OUT x2_n5 VDD_DRV VDD_DRV pfet L=0.55U W=10U
Mx2_XMP6_215 OUT x2_n5 VDD_DRV VDD_DRV pfet L=0.55U W=10U
Mx2_XMP6_216 OUT x2_n5 VDD_DRV VDD_DRV pfet L=0.55U W=10U
Mx2_XMP6_217 OUT x2_n5 VDD_DRV VDD_DRV pfet L=0.55U W=10U
Mx2_XMP6_218 OUT x2_n5 VDD_DRV VDD_DRV pfet L=0.55U W=10U
Mx2_XMP6_219 OUT x2_n5 VDD_DRV VDD_DRV pfet L=0.55U W=10U
Mx2_XMP6_22 OUT x2_n5 VDD_DRV VDD_DRV pfet L=0.55U W=10U
Mx2_XMP6_220 OUT x2_n5 VDD_DRV VDD_DRV pfet L=0.55U W=10U
Mx2_XMP6_221 OUT x2_n5 VDD_DRV VDD_DRV pfet L=0.55U W=10U
Mx2_XMP6_222 OUT x2_n5 VDD_DRV VDD_DRV pfet L=0.55U W=10U
Mx2_XMP6_223 OUT x2_n5 VDD_DRV VDD_DRV pfet L=0.55U W=10U
Mx2_XMP6_224 OUT x2_n5 VDD_DRV VDD_DRV pfet L=0.55U W=10U
Mx2_XMP6_225 OUT x2_n5 VDD_DRV VDD_DRV pfet L=0.55U W=10U
Mx2_XMP6_226 OUT x2_n5 VDD_DRV VDD_DRV pfet L=0.55U W=10U
Mx2_XMP6_227 OUT x2_n5 VDD_DRV VDD_DRV pfet L=0.55U W=10U
Mx2_XMP6_228 OUT x2_n5 VDD_DRV VDD_DRV pfet L=0.55U W=10U
Mx2_XMP6_229 OUT x2_n5 VDD_DRV VDD_DRV pfet L=0.55U W=10U
Mx2_XMP6_23 OUT x2_n5 VDD_DRV VDD_DRV pfet L=0.55U W=10U
Mx2_XMP6_230 OUT x2_n5 VDD_DRV VDD_DRV pfet L=0.55U W=10U
Mx2_XMP6_231 OUT x2_n5 VDD_DRV VDD_DRV pfet L=0.55U W=10U
Mx2_XMP6_232 OUT x2_n5 VDD_DRV VDD_DRV pfet L=0.55U W=10U
Mx2_XMP6_233 OUT x2_n5 VDD_DRV VDD_DRV pfet L=0.55U W=10U
Mx2_XMP6_234 OUT x2_n5 VDD_DRV VDD_DRV pfet L=0.55U W=10U
Mx2_XMP6_235 OUT x2_n5 VDD_DRV VDD_DRV pfet L=0.55U W=10U
Mx2_XMP6_236 OUT x2_n5 VDD_DRV VDD_DRV pfet L=0.55U W=10U
Mx2_XMP6_237 OUT x2_n5 VDD_DRV VDD_DRV pfet L=0.55U W=10U
Mx2_XMP6_238 OUT x2_n5 VDD_DRV VDD_DRV pfet L=0.55U W=10U
Mx2_XMP6_239 OUT x2_n5 VDD_DRV VDD_DRV pfet L=0.55U W=10U
Mx2_XMP6_24 OUT x2_n5 VDD_DRV VDD_DRV pfet L=0.55U W=10U
Mx2_XMP6_240 OUT x2_n5 VDD_DRV VDD_DRV pfet L=0.55U W=10U
Mx2_XMP6_241 OUT x2_n5 VDD_DRV VDD_DRV pfet L=0.55U W=10U
Mx2_XMP6_242 OUT x2_n5 VDD_DRV VDD_DRV pfet L=0.55U W=10U
Mx2_XMP6_243 OUT x2_n5 VDD_DRV VDD_DRV pfet L=0.55U W=10U
Mx2_XMP6_244 OUT x2_n5 VDD_DRV VDD_DRV pfet L=0.55U W=10U
Mx2_XMP6_245 OUT x2_n5 VDD_DRV VDD_DRV pfet L=0.55U W=10U
Mx2_XMP6_246 OUT x2_n5 VDD_DRV VDD_DRV pfet L=0.55U W=10U
Mx2_XMP6_247 OUT x2_n5 VDD_DRV VDD_DRV pfet L=0.55U W=10U
Mx2_XMP6_248 OUT x2_n5 VDD_DRV VDD_DRV pfet L=0.55U W=10U
Mx2_XMP6_249 OUT x2_n5 VDD_DRV VDD_DRV pfet L=0.55U W=10U
Mx2_XMP6_25 OUT x2_n5 VDD_DRV VDD_DRV pfet L=0.55U W=10U
Mx2_XMP6_250 OUT x2_n5 VDD_DRV VDD_DRV pfet L=0.55U W=10U
Mx2_XMP6_251 OUT x2_n5 VDD_DRV VDD_DRV pfet L=0.55U W=10U
Mx2_XMP6_252 OUT x2_n5 VDD_DRV VDD_DRV pfet L=0.55U W=10U
Mx2_XMP6_253 OUT x2_n5 VDD_DRV VDD_DRV pfet L=0.55U W=10U
Mx2_XMP6_254 OUT x2_n5 VDD_DRV VDD_DRV pfet L=0.55U W=10U
Mx2_XMP6_255 OUT x2_n5 VDD_DRV VDD_DRV pfet L=0.55U W=10U
Mx2_XMP6_256 OUT x2_n5 VDD_DRV VDD_DRV pfet L=0.55U W=10U
Mx2_XMP6_257 OUT x2_n5 VDD_DRV VDD_DRV pfet L=0.55U W=10U
Mx2_XMP6_258 OUT x2_n5 VDD_DRV VDD_DRV pfet L=0.55U W=10U
Mx2_XMP6_259 OUT x2_n5 VDD_DRV VDD_DRV pfet L=0.55U W=10U
Mx2_XMP6_26 OUT x2_n5 VDD_DRV VDD_DRV pfet L=0.55U W=10U
Mx2_XMP6_260 OUT x2_n5 VDD_DRV VDD_DRV pfet L=0.55U W=10U
Mx2_XMP6_261 OUT x2_n5 VDD_DRV VDD_DRV pfet L=0.55U W=10U
Mx2_XMP6_262 OUT x2_n5 VDD_DRV VDD_DRV pfet L=0.55U W=10U
Mx2_XMP6_263 OUT x2_n5 VDD_DRV VDD_DRV pfet L=0.55U W=10U
Mx2_XMP6_264 OUT x2_n5 VDD_DRV VDD_DRV pfet L=0.55U W=10U
Mx2_XMP6_265 OUT x2_n5 VDD_DRV VDD_DRV pfet L=0.55U W=10U
Mx2_XMP6_266 OUT x2_n5 VDD_DRV VDD_DRV pfet L=0.55U W=10U
Mx2_XMP6_267 OUT x2_n5 VDD_DRV VDD_DRV pfet L=0.55U W=10U
Mx2_XMP6_268 OUT x2_n5 VDD_DRV VDD_DRV pfet L=0.55U W=10U
Mx2_XMP6_269 OUT x2_n5 VDD_DRV VDD_DRV pfet L=0.55U W=10U
Mx2_XMP6_27 OUT x2_n5 VDD_DRV VDD_DRV pfet L=0.55U W=10U
Mx2_XMP6_270 OUT x2_n5 VDD_DRV VDD_DRV pfet L=0.55U W=10U
Mx2_XMP6_271 OUT x2_n5 VDD_DRV VDD_DRV pfet L=0.55U W=10U
Mx2_XMP6_272 OUT x2_n5 VDD_DRV VDD_DRV pfet L=0.55U W=10U
Mx2_XMP6_273 OUT x2_n5 VDD_DRV VDD_DRV pfet L=0.55U W=10U
Mx2_XMP6_274 OUT x2_n5 VDD_DRV VDD_DRV pfet L=0.55U W=10U
Mx2_XMP6_275 OUT x2_n5 VDD_DRV VDD_DRV pfet L=0.55U W=10U
Mx2_XMP6_276 OUT x2_n5 VDD_DRV VDD_DRV pfet L=0.55U W=10U
Mx2_XMP6_277 OUT x2_n5 VDD_DRV VDD_DRV pfet L=0.55U W=10U
Mx2_XMP6_278 OUT x2_n5 VDD_DRV VDD_DRV pfet L=0.55U W=10U
Mx2_XMP6_279 OUT x2_n5 VDD_DRV VDD_DRV pfet L=0.55U W=10U
Mx2_XMP6_28 OUT x2_n5 VDD_DRV VDD_DRV pfet L=0.55U W=10U
Mx2_XMP6_280 OUT x2_n5 VDD_DRV VDD_DRV pfet L=0.55U W=10U
Mx2_XMP6_281 OUT x2_n5 VDD_DRV VDD_DRV pfet L=0.55U W=10U
Mx2_XMP6_282 OUT x2_n5 VDD_DRV VDD_DRV pfet L=0.55U W=10U
Mx2_XMP6_283 OUT x2_n5 VDD_DRV VDD_DRV pfet L=0.55U W=10U
Mx2_XMP6_284 OUT x2_n5 VDD_DRV VDD_DRV pfet L=0.55U W=10U
Mx2_XMP6_285 OUT x2_n5 VDD_DRV VDD_DRV pfet L=0.55U W=10U
Mx2_XMP6_286 OUT x2_n5 VDD_DRV VDD_DRV pfet L=0.55U W=10U
Mx2_XMP6_287 OUT x2_n5 VDD_DRV VDD_DRV pfet L=0.55U W=10U
Mx2_XMP6_288 OUT x2_n5 VDD_DRV VDD_DRV pfet L=0.55U W=10U
Mx2_XMP6_289 OUT x2_n5 VDD_DRV VDD_DRV pfet L=0.55U W=10U
Mx2_XMP6_29 OUT x2_n5 VDD_DRV VDD_DRV pfet L=0.55U W=10U
Mx2_XMP6_290 OUT x2_n5 VDD_DRV VDD_DRV pfet L=0.55U W=10U
Mx2_XMP6_291 OUT x2_n5 VDD_DRV VDD_DRV pfet L=0.55U W=10U
Mx2_XMP6_292 OUT x2_n5 VDD_DRV VDD_DRV pfet L=0.55U W=10U
Mx2_XMP6_293 OUT x2_n5 VDD_DRV VDD_DRV pfet L=0.55U W=10U
Mx2_XMP6_294 OUT x2_n5 VDD_DRV VDD_DRV pfet L=0.55U W=10U
Mx2_XMP6_295 OUT x2_n5 VDD_DRV VDD_DRV pfet L=0.55U W=10U
Mx2_XMP6_296 OUT x2_n5 VDD_DRV VDD_DRV pfet L=0.55U W=10U
Mx2_XMP6_297 OUT x2_n5 VDD_DRV VDD_DRV pfet L=0.55U W=10U
Mx2_XMP6_298 OUT x2_n5 VDD_DRV VDD_DRV pfet L=0.55U W=10U
Mx2_XMP6_299 OUT x2_n5 VDD_DRV VDD_DRV pfet L=0.55U W=10U
Mx2_XMP6_3 OUT x2_n5 VDD_DRV VDD_DRV pfet L=0.55U W=10U
Mx2_XMP6_30 OUT x2_n5 VDD_DRV VDD_DRV pfet L=0.55U W=10U
Mx2_XMP6_300 OUT x2_n5 VDD_DRV VDD_DRV pfet L=0.55U W=10U
Mx2_XMP6_301 OUT x2_n5 VDD_DRV VDD_DRV pfet L=0.55U W=10U
Mx2_XMP6_302 OUT x2_n5 VDD_DRV VDD_DRV pfet L=0.55U W=10U
Mx2_XMP6_303 OUT x2_n5 VDD_DRV VDD_DRV pfet L=0.55U W=10U
Mx2_XMP6_304 OUT x2_n5 VDD_DRV VDD_DRV pfet L=0.55U W=10U
Mx2_XMP6_305 OUT x2_n5 VDD_DRV VDD_DRV pfet L=0.55U W=10U
Mx2_XMP6_306 OUT x2_n5 VDD_DRV VDD_DRV pfet L=0.55U W=10U
Mx2_XMP6_307 OUT x2_n5 VDD_DRV VDD_DRV pfet L=0.55U W=10U
Mx2_XMP6_308 OUT x2_n5 VDD_DRV VDD_DRV pfet L=0.55U W=10U
Mx2_XMP6_309 OUT x2_n5 VDD_DRV VDD_DRV pfet L=0.55U W=10U
Mx2_XMP6_31 OUT x2_n5 VDD_DRV VDD_DRV pfet L=0.55U W=10U
Mx2_XMP6_310 OUT x2_n5 VDD_DRV VDD_DRV pfet L=0.55U W=10U
Mx2_XMP6_311 OUT x2_n5 VDD_DRV VDD_DRV pfet L=0.55U W=10U
Mx2_XMP6_312 OUT x2_n5 VDD_DRV VDD_DRV pfet L=0.55U W=10U
Mx2_XMP6_313 OUT x2_n5 VDD_DRV VDD_DRV pfet L=0.55U W=10U
Mx2_XMP6_314 OUT x2_n5 VDD_DRV VDD_DRV pfet L=0.55U W=10U
Mx2_XMP6_315 OUT x2_n5 VDD_DRV VDD_DRV pfet L=0.55U W=10U
Mx2_XMP6_316 OUT x2_n5 VDD_DRV VDD_DRV pfet L=0.55U W=10U
Mx2_XMP6_317 OUT x2_n5 VDD_DRV VDD_DRV pfet L=0.55U W=10U
Mx2_XMP6_318 OUT x2_n5 VDD_DRV VDD_DRV pfet L=0.55U W=10U
Mx2_XMP6_319 OUT x2_n5 VDD_DRV VDD_DRV pfet L=0.55U W=10U
Mx2_XMP6_32 OUT x2_n5 VDD_DRV VDD_DRV pfet L=0.55U W=10U
Mx2_XMP6_320 OUT x2_n5 VDD_DRV VDD_DRV pfet L=0.55U W=10U
Mx2_XMP6_321 OUT x2_n5 VDD_DRV VDD_DRV pfet L=0.55U W=10U
Mx2_XMP6_322 OUT x2_n5 VDD_DRV VDD_DRV pfet L=0.55U W=10U
Mx2_XMP6_323 OUT x2_n5 VDD_DRV VDD_DRV pfet L=0.55U W=10U
Mx2_XMP6_324 OUT x2_n5 VDD_DRV VDD_DRV pfet L=0.55U W=10U
Mx2_XMP6_325 OUT x2_n5 VDD_DRV VDD_DRV pfet L=0.55U W=10U
Mx2_XMP6_326 OUT x2_n5 VDD_DRV VDD_DRV pfet L=0.55U W=10U
Mx2_XMP6_327 OUT x2_n5 VDD_DRV VDD_DRV pfet L=0.55U W=10U
Mx2_XMP6_328 OUT x2_n5 VDD_DRV VDD_DRV pfet L=0.55U W=10U
Mx2_XMP6_329 OUT x2_n5 VDD_DRV VDD_DRV pfet L=0.55U W=10U
Mx2_XMP6_33 OUT x2_n5 VDD_DRV VDD_DRV pfet L=0.55U W=10U
Mx2_XMP6_330 OUT x2_n5 VDD_DRV VDD_DRV pfet L=0.55U W=10U
Mx2_XMP6_331 OUT x2_n5 VDD_DRV VDD_DRV pfet L=0.55U W=10U
Mx2_XMP6_332 OUT x2_n5 VDD_DRV VDD_DRV pfet L=0.55U W=10U
Mx2_XMP6_333 OUT x2_n5 VDD_DRV VDD_DRV pfet L=0.55U W=10U
Mx2_XMP6_334 OUT x2_n5 VDD_DRV VDD_DRV pfet L=0.55U W=10U
Mx2_XMP6_335 OUT x2_n5 VDD_DRV VDD_DRV pfet L=0.55U W=10U
Mx2_XMP6_336 OUT x2_n5 VDD_DRV VDD_DRV pfet L=0.55U W=10U
Mx2_XMP6_337 OUT x2_n5 VDD_DRV VDD_DRV pfet L=0.55U W=10U
Mx2_XMP6_338 OUT x2_n5 VDD_DRV VDD_DRV pfet L=0.55U W=10U
Mx2_XMP6_339 OUT x2_n5 VDD_DRV VDD_DRV pfet L=0.55U W=10U
Mx2_XMP6_34 OUT x2_n5 VDD_DRV VDD_DRV pfet L=0.55U W=10U
Mx2_XMP6_340 OUT x2_n5 VDD_DRV VDD_DRV pfet L=0.55U W=10U
Mx2_XMP6_341 OUT x2_n5 VDD_DRV VDD_DRV pfet L=0.55U W=10U
Mx2_XMP6_342 OUT x2_n5 VDD_DRV VDD_DRV pfet L=0.55U W=10U
Mx2_XMP6_343 OUT x2_n5 VDD_DRV VDD_DRV pfet L=0.55U W=10U
Mx2_XMP6_344 OUT x2_n5 VDD_DRV VDD_DRV pfet L=0.55U W=10U
Mx2_XMP6_345 OUT x2_n5 VDD_DRV VDD_DRV pfet L=0.55U W=10U
Mx2_XMP6_346 OUT x2_n5 VDD_DRV VDD_DRV pfet L=0.55U W=10U
Mx2_XMP6_347 OUT x2_n5 VDD_DRV VDD_DRV pfet L=0.55U W=10U
Mx2_XMP6_348 OUT x2_n5 VDD_DRV VDD_DRV pfet L=0.55U W=10U
Mx2_XMP6_349 OUT x2_n5 VDD_DRV VDD_DRV pfet L=0.55U W=10U
Mx2_XMP6_35 OUT x2_n5 VDD_DRV VDD_DRV pfet L=0.55U W=10U
Mx2_XMP6_350 OUT x2_n5 VDD_DRV VDD_DRV pfet L=0.55U W=10U
Mx2_XMP6_351 OUT x2_n5 VDD_DRV VDD_DRV pfet L=0.55U W=10U
Mx2_XMP6_352 OUT x2_n5 VDD_DRV VDD_DRV pfet L=0.55U W=10U
Mx2_XMP6_353 OUT x2_n5 VDD_DRV VDD_DRV pfet L=0.55U W=10U
Mx2_XMP6_354 OUT x2_n5 VDD_DRV VDD_DRV pfet L=0.55U W=10U
Mx2_XMP6_355 OUT x2_n5 VDD_DRV VDD_DRV pfet L=0.55U W=10U
Mx2_XMP6_356 OUT x2_n5 VDD_DRV VDD_DRV pfet L=0.55U W=10U
Mx2_XMP6_357 OUT x2_n5 VDD_DRV VDD_DRV pfet L=0.55U W=10U
Mx2_XMP6_358 OUT x2_n5 VDD_DRV VDD_DRV pfet L=0.55U W=10U
Mx2_XMP6_359 OUT x2_n5 VDD_DRV VDD_DRV pfet L=0.55U W=10U
Mx2_XMP6_36 OUT x2_n5 VDD_DRV VDD_DRV pfet L=0.55U W=10U
Mx2_XMP6_360 OUT x2_n5 VDD_DRV VDD_DRV pfet L=0.55U W=10U
Mx2_XMP6_361 OUT x2_n5 VDD_DRV VDD_DRV pfet L=0.55U W=10U
Mx2_XMP6_362 OUT x2_n5 VDD_DRV VDD_DRV pfet L=0.55U W=10U
Mx2_XMP6_363 OUT x2_n5 VDD_DRV VDD_DRV pfet L=0.55U W=10U
Mx2_XMP6_364 OUT x2_n5 VDD_DRV VDD_DRV pfet L=0.55U W=10U
Mx2_XMP6_365 OUT x2_n5 VDD_DRV VDD_DRV pfet L=0.55U W=10U
Mx2_XMP6_366 OUT x2_n5 VDD_DRV VDD_DRV pfet L=0.55U W=10U
Mx2_XMP6_367 OUT x2_n5 VDD_DRV VDD_DRV pfet L=0.55U W=10U
Mx2_XMP6_368 OUT x2_n5 VDD_DRV VDD_DRV pfet L=0.55U W=10U
Mx2_XMP6_369 OUT x2_n5 VDD_DRV VDD_DRV pfet L=0.55U W=10U
Mx2_XMP6_37 OUT x2_n5 VDD_DRV VDD_DRV pfet L=0.55U W=10U
Mx2_XMP6_370 OUT x2_n5 VDD_DRV VDD_DRV pfet L=0.55U W=10U
Mx2_XMP6_371 OUT x2_n5 VDD_DRV VDD_DRV pfet L=0.55U W=10U
Mx2_XMP6_372 OUT x2_n5 VDD_DRV VDD_DRV pfet L=0.55U W=10U
Mx2_XMP6_373 OUT x2_n5 VDD_DRV VDD_DRV pfet L=0.55U W=10U
Mx2_XMP6_374 OUT x2_n5 VDD_DRV VDD_DRV pfet L=0.55U W=10U
Mx2_XMP6_375 OUT x2_n5 VDD_DRV VDD_DRV pfet L=0.55U W=10U
Mx2_XMP6_376 OUT x2_n5 VDD_DRV VDD_DRV pfet L=0.55U W=10U
Mx2_XMP6_377 OUT x2_n5 VDD_DRV VDD_DRV pfet L=0.55U W=10U
Mx2_XMP6_378 OUT x2_n5 VDD_DRV VDD_DRV pfet L=0.55U W=10U
Mx2_XMP6_379 OUT x2_n5 VDD_DRV VDD_DRV pfet L=0.55U W=10U
Mx2_XMP6_38 OUT x2_n5 VDD_DRV VDD_DRV pfet L=0.55U W=10U
Mx2_XMP6_380 OUT x2_n5 VDD_DRV VDD_DRV pfet L=0.55U W=10U
Mx2_XMP6_381 OUT x2_n5 VDD_DRV VDD_DRV pfet L=0.55U W=10U
Mx2_XMP6_382 OUT x2_n5 VDD_DRV VDD_DRV pfet L=0.55U W=10U
Mx2_XMP6_383 OUT x2_n5 VDD_DRV VDD_DRV pfet L=0.55U W=10U
Mx2_XMP6_384 OUT x2_n5 VDD_DRV VDD_DRV pfet L=0.55U W=10U
Mx2_XMP6_385 OUT x2_n5 VDD_DRV VDD_DRV pfet L=0.55U W=10U
Mx2_XMP6_386 OUT x2_n5 VDD_DRV VDD_DRV pfet L=0.55U W=10U
Mx2_XMP6_387 OUT x2_n5 VDD_DRV VDD_DRV pfet L=0.55U W=10U
Mx2_XMP6_388 OUT x2_n5 VDD_DRV VDD_DRV pfet L=0.55U W=10U
Mx2_XMP6_389 OUT x2_n5 VDD_DRV VDD_DRV pfet L=0.55U W=10U
Mx2_XMP6_39 OUT x2_n5 VDD_DRV VDD_DRV pfet L=0.55U W=10U
Mx2_XMP6_390 OUT x2_n5 VDD_DRV VDD_DRV pfet L=0.55U W=10U
Mx2_XMP6_391 OUT x2_n5 VDD_DRV VDD_DRV pfet L=0.55U W=10U
Mx2_XMP6_392 OUT x2_n5 VDD_DRV VDD_DRV pfet L=0.55U W=10U
Mx2_XMP6_393 OUT x2_n5 VDD_DRV VDD_DRV pfet L=0.55U W=10U
Mx2_XMP6_394 OUT x2_n5 VDD_DRV VDD_DRV pfet L=0.55U W=10U
Mx2_XMP6_395 OUT x2_n5 VDD_DRV VDD_DRV pfet L=0.55U W=10U
Mx2_XMP6_396 OUT x2_n5 VDD_DRV VDD_DRV pfet L=0.55U W=10U
Mx2_XMP6_397 OUT x2_n5 VDD_DRV VDD_DRV pfet L=0.55U W=10U
Mx2_XMP6_398 OUT x2_n5 VDD_DRV VDD_DRV pfet L=0.55U W=10U
Mx2_XMP6_399 OUT x2_n5 VDD_DRV VDD_DRV pfet L=0.55U W=10U
Mx2_XMP6_4 OUT x2_n5 VDD_DRV VDD_DRV pfet L=0.55U W=10U
Mx2_XMP6_40 OUT x2_n5 VDD_DRV VDD_DRV pfet L=0.55U W=10U
Mx2_XMP6_400 OUT x2_n5 VDD_DRV VDD_DRV pfet L=0.55U W=10U
Mx2_XMP6_401 OUT x2_n5 VDD_DRV VDD_DRV pfet L=0.55U W=10U
Mx2_XMP6_402 OUT x2_n5 VDD_DRV VDD_DRV pfet L=0.55U W=10U
Mx2_XMP6_403 OUT x2_n5 VDD_DRV VDD_DRV pfet L=0.55U W=10U
Mx2_XMP6_404 OUT x2_n5 VDD_DRV VDD_DRV pfet L=0.55U W=10U
Mx2_XMP6_405 OUT x2_n5 VDD_DRV VDD_DRV pfet L=0.55U W=10U
Mx2_XMP6_406 OUT x2_n5 VDD_DRV VDD_DRV pfet L=0.55U W=10U
Mx2_XMP6_407 OUT x2_n5 VDD_DRV VDD_DRV pfet L=0.55U W=10U
Mx2_XMP6_408 OUT x2_n5 VDD_DRV VDD_DRV pfet L=0.55U W=10U
Mx2_XMP6_409 OUT x2_n5 VDD_DRV VDD_DRV pfet L=0.55U W=10U
Mx2_XMP6_41 OUT x2_n5 VDD_DRV VDD_DRV pfet L=0.55U W=10U
Mx2_XMP6_410 OUT x2_n5 VDD_DRV VDD_DRV pfet L=0.55U W=10U
Mx2_XMP6_411 OUT x2_n5 VDD_DRV VDD_DRV pfet L=0.55U W=10U
Mx2_XMP6_412 OUT x2_n5 VDD_DRV VDD_DRV pfet L=0.55U W=10U
Mx2_XMP6_413 OUT x2_n5 VDD_DRV VDD_DRV pfet L=0.55U W=10U
Mx2_XMP6_414 OUT x2_n5 VDD_DRV VDD_DRV pfet L=0.55U W=10U
Mx2_XMP6_415 OUT x2_n5 VDD_DRV VDD_DRV pfet L=0.55U W=10U
Mx2_XMP6_416 OUT x2_n5 VDD_DRV VDD_DRV pfet L=0.55U W=10U
Mx2_XMP6_417 OUT x2_n5 VDD_DRV VDD_DRV pfet L=0.55U W=10U
Mx2_XMP6_418 OUT x2_n5 VDD_DRV VDD_DRV pfet L=0.55U W=10U
Mx2_XMP6_419 OUT x2_n5 VDD_DRV VDD_DRV pfet L=0.55U W=10U
Mx2_XMP6_42 OUT x2_n5 VDD_DRV VDD_DRV pfet L=0.55U W=10U
Mx2_XMP6_420 OUT x2_n5 VDD_DRV VDD_DRV pfet L=0.55U W=10U
Mx2_XMP6_421 OUT x2_n5 VDD_DRV VDD_DRV pfet L=0.55U W=10U
Mx2_XMP6_422 OUT x2_n5 VDD_DRV VDD_DRV pfet L=0.55U W=10U
Mx2_XMP6_423 OUT x2_n5 VDD_DRV VDD_DRV pfet L=0.55U W=10U
Mx2_XMP6_424 OUT x2_n5 VDD_DRV VDD_DRV pfet L=0.55U W=10U
Mx2_XMP6_425 OUT x2_n5 VDD_DRV VDD_DRV pfet L=0.55U W=10U
Mx2_XMP6_426 OUT x2_n5 VDD_DRV VDD_DRV pfet L=0.55U W=10U
Mx2_XMP6_427 OUT x2_n5 VDD_DRV VDD_DRV pfet L=0.55U W=10U
Mx2_XMP6_428 OUT x2_n5 VDD_DRV VDD_DRV pfet L=0.55U W=10U
Mx2_XMP6_429 OUT x2_n5 VDD_DRV VDD_DRV pfet L=0.55U W=10U
Mx2_XMP6_43 OUT x2_n5 VDD_DRV VDD_DRV pfet L=0.55U W=10U
Mx2_XMP6_430 OUT x2_n5 VDD_DRV VDD_DRV pfet L=0.55U W=10U
Mx2_XMP6_431 OUT x2_n5 VDD_DRV VDD_DRV pfet L=0.55U W=10U
Mx2_XMP6_432 OUT x2_n5 VDD_DRV VDD_DRV pfet L=0.55U W=10U
Mx2_XMP6_433 OUT x2_n5 VDD_DRV VDD_DRV pfet L=0.55U W=10U
Mx2_XMP6_434 OUT x2_n5 VDD_DRV VDD_DRV pfet L=0.55U W=10U
Mx2_XMP6_435 OUT x2_n5 VDD_DRV VDD_DRV pfet L=0.55U W=10U
Mx2_XMP6_436 OUT x2_n5 VDD_DRV VDD_DRV pfet L=0.55U W=10U
Mx2_XMP6_437 OUT x2_n5 VDD_DRV VDD_DRV pfet L=0.55U W=10U
Mx2_XMP6_438 OUT x2_n5 VDD_DRV VDD_DRV pfet L=0.55U W=10U
Mx2_XMP6_439 OUT x2_n5 VDD_DRV VDD_DRV pfet L=0.55U W=10U
Mx2_XMP6_44 OUT x2_n5 VDD_DRV VDD_DRV pfet L=0.55U W=10U
Mx2_XMP6_440 OUT x2_n5 VDD_DRV VDD_DRV pfet L=0.55U W=10U
Mx2_XMP6_441 OUT x2_n5 VDD_DRV VDD_DRV pfet L=0.55U W=10U
Mx2_XMP6_442 OUT x2_n5 VDD_DRV VDD_DRV pfet L=0.55U W=10U
Mx2_XMP6_443 OUT x2_n5 VDD_DRV VDD_DRV pfet L=0.55U W=10U
Mx2_XMP6_444 OUT x2_n5 VDD_DRV VDD_DRV pfet L=0.55U W=10U
Mx2_XMP6_445 OUT x2_n5 VDD_DRV VDD_DRV pfet L=0.55U W=10U
Mx2_XMP6_446 OUT x2_n5 VDD_DRV VDD_DRV pfet L=0.55U W=10U
Mx2_XMP6_447 OUT x2_n5 VDD_DRV VDD_DRV pfet L=0.55U W=10U
Mx2_XMP6_448 OUT x2_n5 VDD_DRV VDD_DRV pfet L=0.55U W=10U
Mx2_XMP6_449 OUT x2_n5 VDD_DRV VDD_DRV pfet L=0.55U W=10U
Mx2_XMP6_45 OUT x2_n5 VDD_DRV VDD_DRV pfet L=0.55U W=10U
Mx2_XMP6_450 OUT x2_n5 VDD_DRV VDD_DRV pfet L=0.55U W=10U
Mx2_XMP6_451 OUT x2_n5 VDD_DRV VDD_DRV pfet L=0.55U W=10U
Mx2_XMP6_452 OUT x2_n5 VDD_DRV VDD_DRV pfet L=0.55U W=10U
Mx2_XMP6_453 OUT x2_n5 VDD_DRV VDD_DRV pfet L=0.55U W=10U
Mx2_XMP6_454 OUT x2_n5 VDD_DRV VDD_DRV pfet L=0.55U W=10U
Mx2_XMP6_455 OUT x2_n5 VDD_DRV VDD_DRV pfet L=0.55U W=10U
Mx2_XMP6_456 OUT x2_n5 VDD_DRV VDD_DRV pfet L=0.55U W=10U
Mx2_XMP6_457 OUT x2_n5 VDD_DRV VDD_DRV pfet L=0.55U W=10U
Mx2_XMP6_458 OUT x2_n5 VDD_DRV VDD_DRV pfet L=0.55U W=10U
Mx2_XMP6_459 OUT x2_n5 VDD_DRV VDD_DRV pfet L=0.55U W=10U
Mx2_XMP6_46 OUT x2_n5 VDD_DRV VDD_DRV pfet L=0.55U W=10U
Mx2_XMP6_460 OUT x2_n5 VDD_DRV VDD_DRV pfet L=0.55U W=10U
Mx2_XMP6_461 OUT x2_n5 VDD_DRV VDD_DRV pfet L=0.55U W=10U
Mx2_XMP6_462 OUT x2_n5 VDD_DRV VDD_DRV pfet L=0.55U W=10U
Mx2_XMP6_463 OUT x2_n5 VDD_DRV VDD_DRV pfet L=0.55U W=10U
Mx2_XMP6_464 OUT x2_n5 VDD_DRV VDD_DRV pfet L=0.55U W=10U
Mx2_XMP6_465 OUT x2_n5 VDD_DRV VDD_DRV pfet L=0.55U W=10U
Mx2_XMP6_466 OUT x2_n5 VDD_DRV VDD_DRV pfet L=0.55U W=10U
Mx2_XMP6_467 OUT x2_n5 VDD_DRV VDD_DRV pfet L=0.55U W=10U
Mx2_XMP6_468 OUT x2_n5 VDD_DRV VDD_DRV pfet L=0.55U W=10U
Mx2_XMP6_469 OUT x2_n5 VDD_DRV VDD_DRV pfet L=0.55U W=10U
Mx2_XMP6_47 OUT x2_n5 VDD_DRV VDD_DRV pfet L=0.55U W=10U
Mx2_XMP6_470 OUT x2_n5 VDD_DRV VDD_DRV pfet L=0.55U W=10U
Mx2_XMP6_471 OUT x2_n5 VDD_DRV VDD_DRV pfet L=0.55U W=10U
Mx2_XMP6_472 OUT x2_n5 VDD_DRV VDD_DRV pfet L=0.55U W=10U
Mx2_XMP6_473 OUT x2_n5 VDD_DRV VDD_DRV pfet L=0.55U W=10U
Mx2_XMP6_474 OUT x2_n5 VDD_DRV VDD_DRV pfet L=0.55U W=10U
Mx2_XMP6_475 OUT x2_n5 VDD_DRV VDD_DRV pfet L=0.55U W=10U
Mx2_XMP6_476 OUT x2_n5 VDD_DRV VDD_DRV pfet L=0.55U W=10U
Mx2_XMP6_477 OUT x2_n5 VDD_DRV VDD_DRV pfet L=0.55U W=10U
Mx2_XMP6_478 OUT x2_n5 VDD_DRV VDD_DRV pfet L=0.55U W=10U
Mx2_XMP6_479 OUT x2_n5 VDD_DRV VDD_DRV pfet L=0.55U W=10U
Mx2_XMP6_48 OUT x2_n5 VDD_DRV VDD_DRV pfet L=0.55U W=10U
Mx2_XMP6_480 OUT x2_n5 VDD_DRV VDD_DRV pfet L=0.55U W=10U
Mx2_XMP6_481 OUT x2_n5 VDD_DRV VDD_DRV pfet L=0.55U W=10U
Mx2_XMP6_482 OUT x2_n5 VDD_DRV VDD_DRV pfet L=0.55U W=10U
Mx2_XMP6_483 OUT x2_n5 VDD_DRV VDD_DRV pfet L=0.55U W=10U
Mx2_XMP6_484 OUT x2_n5 VDD_DRV VDD_DRV pfet L=0.55U W=10U
Mx2_XMP6_485 OUT x2_n5 VDD_DRV VDD_DRV pfet L=0.55U W=10U
Mx2_XMP6_486 OUT x2_n5 VDD_DRV VDD_DRV pfet L=0.55U W=10U
Mx2_XMP6_487 OUT x2_n5 VDD_DRV VDD_DRV pfet L=0.55U W=10U
Mx2_XMP6_488 OUT x2_n5 VDD_DRV VDD_DRV pfet L=0.55U W=10U
Mx2_XMP6_489 OUT x2_n5 VDD_DRV VDD_DRV pfet L=0.55U W=10U
Mx2_XMP6_49 OUT x2_n5 VDD_DRV VDD_DRV pfet L=0.55U W=10U
Mx2_XMP6_490 OUT x2_n5 VDD_DRV VDD_DRV pfet L=0.55U W=10U
Mx2_XMP6_491 OUT x2_n5 VDD_DRV VDD_DRV pfet L=0.55U W=10U
Mx2_XMP6_492 OUT x2_n5 VDD_DRV VDD_DRV pfet L=0.55U W=10U
Mx2_XMP6_493 OUT x2_n5 VDD_DRV VDD_DRV pfet L=0.55U W=10U
Mx2_XMP6_494 OUT x2_n5 VDD_DRV VDD_DRV pfet L=0.55U W=10U
Mx2_XMP6_495 OUT x2_n5 VDD_DRV VDD_DRV pfet L=0.55U W=10U
Mx2_XMP6_496 OUT x2_n5 VDD_DRV VDD_DRV pfet L=0.55U W=10U
Mx2_XMP6_497 OUT x2_n5 VDD_DRV VDD_DRV pfet L=0.55U W=10U
Mx2_XMP6_498 OUT x2_n5 VDD_DRV VDD_DRV pfet L=0.55U W=10U
Mx2_XMP6_499 OUT x2_n5 VDD_DRV VDD_DRV pfet L=0.55U W=10U
Mx2_XMP6_5 OUT x2_n5 VDD_DRV VDD_DRV pfet L=0.55U W=10U
Mx2_XMP6_50 OUT x2_n5 VDD_DRV VDD_DRV pfet L=0.55U W=10U
Mx2_XMP6_51 OUT x2_n5 VDD_DRV VDD_DRV pfet L=0.55U W=10U
Mx2_XMP6_52 OUT x2_n5 VDD_DRV VDD_DRV pfet L=0.55U W=10U
Mx2_XMP6_53 OUT x2_n5 VDD_DRV VDD_DRV pfet L=0.55U W=10U
Mx2_XMP6_54 OUT x2_n5 VDD_DRV VDD_DRV pfet L=0.55U W=10U
Mx2_XMP6_55 OUT x2_n5 VDD_DRV VDD_DRV pfet L=0.55U W=10U
Mx2_XMP6_56 OUT x2_n5 VDD_DRV VDD_DRV pfet L=0.55U W=10U
Mx2_XMP6_57 OUT x2_n5 VDD_DRV VDD_DRV pfet L=0.55U W=10U
Mx2_XMP6_58 OUT x2_n5 VDD_DRV VDD_DRV pfet L=0.55U W=10U
Mx2_XMP6_59 OUT x2_n5 VDD_DRV VDD_DRV pfet L=0.55U W=10U
Mx2_XMP6_6 OUT x2_n5 VDD_DRV VDD_DRV pfet L=0.55U W=10U
Mx2_XMP6_60 OUT x2_n5 VDD_DRV VDD_DRV pfet L=0.55U W=10U
Mx2_XMP6_61 OUT x2_n5 VDD_DRV VDD_DRV pfet L=0.55U W=10U
Mx2_XMP6_62 OUT x2_n5 VDD_DRV VDD_DRV pfet L=0.55U W=10U
Mx2_XMP6_63 OUT x2_n5 VDD_DRV VDD_DRV pfet L=0.55U W=10U
Mx2_XMP6_64 OUT x2_n5 VDD_DRV VDD_DRV pfet L=0.55U W=10U
Mx2_XMP6_65 OUT x2_n5 VDD_DRV VDD_DRV pfet L=0.55U W=10U
Mx2_XMP6_66 OUT x2_n5 VDD_DRV VDD_DRV pfet L=0.55U W=10U
Mx2_XMP6_67 OUT x2_n5 VDD_DRV VDD_DRV pfet L=0.55U W=10U
Mx2_XMP6_68 OUT x2_n5 VDD_DRV VDD_DRV pfet L=0.55U W=10U
Mx2_XMP6_69 OUT x2_n5 VDD_DRV VDD_DRV pfet L=0.55U W=10U
Mx2_XMP6_7 OUT x2_n5 VDD_DRV VDD_DRV pfet L=0.55U W=10U
Mx2_XMP6_70 OUT x2_n5 VDD_DRV VDD_DRV pfet L=0.55U W=10U
Mx2_XMP6_71 OUT x2_n5 VDD_DRV VDD_DRV pfet L=0.55U W=10U
Mx2_XMP6_72 OUT x2_n5 VDD_DRV VDD_DRV pfet L=0.55U W=10U
Mx2_XMP6_73 OUT x2_n5 VDD_DRV VDD_DRV pfet L=0.55U W=10U
Mx2_XMP6_74 OUT x2_n5 VDD_DRV VDD_DRV pfet L=0.55U W=10U
Mx2_XMP6_75 OUT x2_n5 VDD_DRV VDD_DRV pfet L=0.55U W=10U
Mx2_XMP6_76 OUT x2_n5 VDD_DRV VDD_DRV pfet L=0.55U W=10U
Mx2_XMP6_77 OUT x2_n5 VDD_DRV VDD_DRV pfet L=0.55U W=10U
Mx2_XMP6_78 OUT x2_n5 VDD_DRV VDD_DRV pfet L=0.55U W=10U
Mx2_XMP6_79 OUT x2_n5 VDD_DRV VDD_DRV pfet L=0.55U W=10U
Mx2_XMP6_8 OUT x2_n5 VDD_DRV VDD_DRV pfet L=0.55U W=10U
Mx2_XMP6_80 OUT x2_n5 VDD_DRV VDD_DRV pfet L=0.55U W=10U
Mx2_XMP6_81 OUT x2_n5 VDD_DRV VDD_DRV pfet L=0.55U W=10U
Mx2_XMP6_82 OUT x2_n5 VDD_DRV VDD_DRV pfet L=0.55U W=10U
Mx2_XMP6_83 OUT x2_n5 VDD_DRV VDD_DRV pfet L=0.55U W=10U
Mx2_XMP6_84 OUT x2_n5 VDD_DRV VDD_DRV pfet L=0.55U W=10U
Mx2_XMP6_85 OUT x2_n5 VDD_DRV VDD_DRV pfet L=0.55U W=10U
Mx2_XMP6_86 OUT x2_n5 VDD_DRV VDD_DRV pfet L=0.55U W=10U
Mx2_XMP6_87 OUT x2_n5 VDD_DRV VDD_DRV pfet L=0.55U W=10U
Mx2_XMP6_88 OUT x2_n5 VDD_DRV VDD_DRV pfet L=0.55U W=10U
Mx2_XMP6_89 OUT x2_n5 VDD_DRV VDD_DRV pfet L=0.55U W=10U
Mx2_XMP6_9 OUT x2_n5 VDD_DRV VDD_DRV pfet L=0.55U W=10U
Mx2_XMP6_90 OUT x2_n5 VDD_DRV VDD_DRV pfet L=0.55U W=10U
Mx2_XMP6_91 OUT x2_n5 VDD_DRV VDD_DRV pfet L=0.55U W=10U
Mx2_XMP6_92 OUT x2_n5 VDD_DRV VDD_DRV pfet L=0.55U W=10U
Mx2_XMP6_93 OUT x2_n5 VDD_DRV VDD_DRV pfet L=0.55U W=10U
Mx2_XMP6_94 OUT x2_n5 VDD_DRV VDD_DRV pfet L=0.55U W=10U
Mx2_XMP6_95 OUT x2_n5 VDD_DRV VDD_DRV pfet L=0.55U W=10U
Mx2_XMP6_96 OUT x2_n5 VDD_DRV VDD_DRV pfet L=0.55U W=10U
Mx2_XMP6_97 OUT x2_n5 VDD_DRV VDD_DRV pfet L=0.55U W=10U
Mx2_XMP6_98 OUT x2_n5 VDD_DRV VDD_DRV pfet L=0.55U W=10U
Mx2_XMP6_99 OUT x2_n5 VDD_DRV VDD_DRV pfet L=0.55U W=10U
Mx3_XMINN_0 x3_ncompn x3_nref x3_ntail GND_LOGIC nfet L=0.7U W=15U
Mx3_XMINP_0 x3_ncompp x3_ndiv x3_ntail GND_LOGIC nfet L=0.7U W=15U
Mx3_XMLOADN_0 x3_ncompn x3_ncompp VDD_DRV VDD_DRV pfet L=0.55U W=15U
Mx3_XMLOADP_0 x3_ncompp x3_ncompp VDD_DRV VDD_DRV pfet L=0.55U W=15U
Mx3_XMNINV1_0 x3_lockout x3_ncompn GND_DRV GND_LOGIC nfet L=0.7U W=5U
Mx3_XMNINV2_0 x3_uvlo_ok x3_lockout GND_DRV GND_LOGIC nfet L=0.7U W=10U
Mx3_XMPD_0 OUT x3_lockout GND_DRV GND_LOGIC nfet L=0.7U W=10U
Mx3_XMPD_1 OUT x3_lockout GND_DRV GND_LOGIC nfet L=0.7U W=10U
Mx3_XMPD_10 OUT x3_lockout GND_DRV GND_LOGIC nfet L=0.7U W=10U
Mx3_XMPD_100 OUT x3_lockout GND_DRV GND_LOGIC nfet L=0.7U W=10U
Mx3_XMPD_101 OUT x3_lockout GND_DRV GND_LOGIC nfet L=0.7U W=10U
Mx3_XMPD_102 OUT x3_lockout GND_DRV GND_LOGIC nfet L=0.7U W=10U
Mx3_XMPD_103 OUT x3_lockout GND_DRV GND_LOGIC nfet L=0.7U W=10U
Mx3_XMPD_104 OUT x3_lockout GND_DRV GND_LOGIC nfet L=0.7U W=10U
Mx3_XMPD_105 OUT x3_lockout GND_DRV GND_LOGIC nfet L=0.7U W=10U
Mx3_XMPD_106 OUT x3_lockout GND_DRV GND_LOGIC nfet L=0.7U W=10U
Mx3_XMPD_107 OUT x3_lockout GND_DRV GND_LOGIC nfet L=0.7U W=10U
Mx3_XMPD_108 OUT x3_lockout GND_DRV GND_LOGIC nfet L=0.7U W=10U
Mx3_XMPD_109 OUT x3_lockout GND_DRV GND_LOGIC nfet L=0.7U W=10U
Mx3_XMPD_11 OUT x3_lockout GND_DRV GND_LOGIC nfet L=0.7U W=10U
Mx3_XMPD_110 OUT x3_lockout GND_DRV GND_LOGIC nfet L=0.7U W=10U
Mx3_XMPD_111 OUT x3_lockout GND_DRV GND_LOGIC nfet L=0.7U W=10U
Mx3_XMPD_112 OUT x3_lockout GND_DRV GND_LOGIC nfet L=0.7U W=10U
Mx3_XMPD_113 OUT x3_lockout GND_DRV GND_LOGIC nfet L=0.7U W=10U
Mx3_XMPD_114 OUT x3_lockout GND_DRV GND_LOGIC nfet L=0.7U W=10U
Mx3_XMPD_115 OUT x3_lockout GND_DRV GND_LOGIC nfet L=0.7U W=10U
Mx3_XMPD_116 OUT x3_lockout GND_DRV GND_LOGIC nfet L=0.7U W=10U
Mx3_XMPD_117 OUT x3_lockout GND_DRV GND_LOGIC nfet L=0.7U W=10U
Mx3_XMPD_118 OUT x3_lockout GND_DRV GND_LOGIC nfet L=0.7U W=10U
Mx3_XMPD_119 OUT x3_lockout GND_DRV GND_LOGIC nfet L=0.7U W=10U
Mx3_XMPD_12 OUT x3_lockout GND_DRV GND_LOGIC nfet L=0.7U W=10U
Mx3_XMPD_120 OUT x3_lockout GND_DRV GND_LOGIC nfet L=0.7U W=10U
Mx3_XMPD_121 OUT x3_lockout GND_DRV GND_LOGIC nfet L=0.7U W=10U
Mx3_XMPD_122 OUT x3_lockout GND_DRV GND_LOGIC nfet L=0.7U W=10U
Mx3_XMPD_123 OUT x3_lockout GND_DRV GND_LOGIC nfet L=0.7U W=10U
Mx3_XMPD_124 OUT x3_lockout GND_DRV GND_LOGIC nfet L=0.7U W=10U
Mx3_XMPD_125 OUT x3_lockout GND_DRV GND_LOGIC nfet L=0.7U W=10U
Mx3_XMPD_126 OUT x3_lockout GND_DRV GND_LOGIC nfet L=0.7U W=10U
Mx3_XMPD_127 OUT x3_lockout GND_DRV GND_LOGIC nfet L=0.7U W=10U
Mx3_XMPD_128 OUT x3_lockout GND_DRV GND_LOGIC nfet L=0.7U W=10U
Mx3_XMPD_129 OUT x3_lockout GND_DRV GND_LOGIC nfet L=0.7U W=10U
Mx3_XMPD_13 OUT x3_lockout GND_DRV GND_LOGIC nfet L=0.7U W=10U
Mx3_XMPD_130 OUT x3_lockout GND_DRV GND_LOGIC nfet L=0.7U W=10U
Mx3_XMPD_131 OUT x3_lockout GND_DRV GND_LOGIC nfet L=0.7U W=10U
Mx3_XMPD_132 OUT x3_lockout GND_DRV GND_LOGIC nfet L=0.7U W=10U
Mx3_XMPD_133 OUT x3_lockout GND_DRV GND_LOGIC nfet L=0.7U W=10U
Mx3_XMPD_134 OUT x3_lockout GND_DRV GND_LOGIC nfet L=0.7U W=10U
Mx3_XMPD_135 OUT x3_lockout GND_DRV GND_LOGIC nfet L=0.7U W=10U
Mx3_XMPD_136 OUT x3_lockout GND_DRV GND_LOGIC nfet L=0.7U W=10U
Mx3_XMPD_137 OUT x3_lockout GND_DRV GND_LOGIC nfet L=0.7U W=10U
Mx3_XMPD_138 OUT x3_lockout GND_DRV GND_LOGIC nfet L=0.7U W=10U
Mx3_XMPD_139 OUT x3_lockout GND_DRV GND_LOGIC nfet L=0.7U W=10U
Mx3_XMPD_14 OUT x3_lockout GND_DRV GND_LOGIC nfet L=0.7U W=10U
Mx3_XMPD_140 OUT x3_lockout GND_DRV GND_LOGIC nfet L=0.7U W=10U
Mx3_XMPD_141 OUT x3_lockout GND_DRV GND_LOGIC nfet L=0.7U W=10U
Mx3_XMPD_142 OUT x3_lockout GND_DRV GND_LOGIC nfet L=0.7U W=10U
Mx3_XMPD_143 OUT x3_lockout GND_DRV GND_LOGIC nfet L=0.7U W=10U
Mx3_XMPD_144 OUT x3_lockout GND_DRV GND_LOGIC nfet L=0.7U W=10U
Mx3_XMPD_145 OUT x3_lockout GND_DRV GND_LOGIC nfet L=0.7U W=10U
Mx3_XMPD_146 OUT x3_lockout GND_DRV GND_LOGIC nfet L=0.7U W=10U
Mx3_XMPD_147 OUT x3_lockout GND_DRV GND_LOGIC nfet L=0.7U W=10U
Mx3_XMPD_148 OUT x3_lockout GND_DRV GND_LOGIC nfet L=0.7U W=10U
Mx3_XMPD_149 OUT x3_lockout GND_DRV GND_LOGIC nfet L=0.7U W=10U
Mx3_XMPD_15 OUT x3_lockout GND_DRV GND_LOGIC nfet L=0.7U W=10U
Mx3_XMPD_150 OUT x3_lockout GND_DRV GND_LOGIC nfet L=0.7U W=10U
Mx3_XMPD_151 OUT x3_lockout GND_DRV GND_LOGIC nfet L=0.7U W=10U
Mx3_XMPD_152 OUT x3_lockout GND_DRV GND_LOGIC nfet L=0.7U W=10U
Mx3_XMPD_153 OUT x3_lockout GND_DRV GND_LOGIC nfet L=0.7U W=10U
Mx3_XMPD_154 OUT x3_lockout GND_DRV GND_LOGIC nfet L=0.7U W=10U
Mx3_XMPD_155 OUT x3_lockout GND_DRV GND_LOGIC nfet L=0.7U W=10U
Mx3_XMPD_156 OUT x3_lockout GND_DRV GND_LOGIC nfet L=0.7U W=10U
Mx3_XMPD_157 OUT x3_lockout GND_DRV GND_LOGIC nfet L=0.7U W=10U
Mx3_XMPD_158 OUT x3_lockout GND_DRV GND_LOGIC nfet L=0.7U W=10U
Mx3_XMPD_159 OUT x3_lockout GND_DRV GND_LOGIC nfet L=0.7U W=10U
Mx3_XMPD_16 OUT x3_lockout GND_DRV GND_LOGIC nfet L=0.7U W=10U
Mx3_XMPD_160 OUT x3_lockout GND_DRV GND_LOGIC nfet L=0.7U W=10U
Mx3_XMPD_161 OUT x3_lockout GND_DRV GND_LOGIC nfet L=0.7U W=10U
Mx3_XMPD_162 OUT x3_lockout GND_DRV GND_LOGIC nfet L=0.7U W=10U
Mx3_XMPD_163 OUT x3_lockout GND_DRV GND_LOGIC nfet L=0.7U W=10U
Mx3_XMPD_164 OUT x3_lockout GND_DRV GND_LOGIC nfet L=0.7U W=10U
Mx3_XMPD_165 OUT x3_lockout GND_DRV GND_LOGIC nfet L=0.7U W=10U
Mx3_XMPD_166 OUT x3_lockout GND_DRV GND_LOGIC nfet L=0.7U W=10U
Mx3_XMPD_167 OUT x3_lockout GND_DRV GND_LOGIC nfet L=0.7U W=10U
Mx3_XMPD_168 OUT x3_lockout GND_DRV GND_LOGIC nfet L=0.7U W=10U
Mx3_XMPD_169 OUT x3_lockout GND_DRV GND_LOGIC nfet L=0.7U W=10U
Mx3_XMPD_17 OUT x3_lockout GND_DRV GND_LOGIC nfet L=0.7U W=10U
Mx3_XMPD_170 OUT x3_lockout GND_DRV GND_LOGIC nfet L=0.7U W=10U
Mx3_XMPD_171 OUT x3_lockout GND_DRV GND_LOGIC nfet L=0.7U W=10U
Mx3_XMPD_172 OUT x3_lockout GND_DRV GND_LOGIC nfet L=0.7U W=10U
Mx3_XMPD_173 OUT x3_lockout GND_DRV GND_LOGIC nfet L=0.7U W=10U
Mx3_XMPD_174 OUT x3_lockout GND_DRV GND_LOGIC nfet L=0.7U W=10U
Mx3_XMPD_175 OUT x3_lockout GND_DRV GND_LOGIC nfet L=0.7U W=10U
Mx3_XMPD_176 OUT x3_lockout GND_DRV GND_LOGIC nfet L=0.7U W=10U
Mx3_XMPD_177 OUT x3_lockout GND_DRV GND_LOGIC nfet L=0.7U W=10U
Mx3_XMPD_178 OUT x3_lockout GND_DRV GND_LOGIC nfet L=0.7U W=10U
Mx3_XMPD_179 OUT x3_lockout GND_DRV GND_LOGIC nfet L=0.7U W=10U
Mx3_XMPD_18 OUT x3_lockout GND_DRV GND_LOGIC nfet L=0.7U W=10U
Mx3_XMPD_180 OUT x3_lockout GND_DRV GND_LOGIC nfet L=0.7U W=10U
Mx3_XMPD_181 OUT x3_lockout GND_DRV GND_LOGIC nfet L=0.7U W=10U
Mx3_XMPD_182 OUT x3_lockout GND_DRV GND_LOGIC nfet L=0.7U W=10U
Mx3_XMPD_183 OUT x3_lockout GND_DRV GND_LOGIC nfet L=0.7U W=10U
Mx3_XMPD_184 OUT x3_lockout GND_DRV GND_LOGIC nfet L=0.7U W=10U
Mx3_XMPD_185 OUT x3_lockout GND_DRV GND_LOGIC nfet L=0.7U W=10U
Mx3_XMPD_186 OUT x3_lockout GND_DRV GND_LOGIC nfet L=0.7U W=10U
Mx3_XMPD_187 OUT x3_lockout GND_DRV GND_LOGIC nfet L=0.7U W=10U
Mx3_XMPD_188 OUT x3_lockout GND_DRV GND_LOGIC nfet L=0.7U W=10U
Mx3_XMPD_189 OUT x3_lockout GND_DRV GND_LOGIC nfet L=0.7U W=10U
Mx3_XMPD_19 OUT x3_lockout GND_DRV GND_LOGIC nfet L=0.7U W=10U
Mx3_XMPD_190 OUT x3_lockout GND_DRV GND_LOGIC nfet L=0.7U W=10U
Mx3_XMPD_191 OUT x3_lockout GND_DRV GND_LOGIC nfet L=0.7U W=10U
Mx3_XMPD_192 OUT x3_lockout GND_DRV GND_LOGIC nfet L=0.7U W=10U
Mx3_XMPD_193 OUT x3_lockout GND_DRV GND_LOGIC nfet L=0.7U W=10U
Mx3_XMPD_194 OUT x3_lockout GND_DRV GND_LOGIC nfet L=0.7U W=10U
Mx3_XMPD_195 OUT x3_lockout GND_DRV GND_LOGIC nfet L=0.7U W=10U
Mx3_XMPD_196 OUT x3_lockout GND_DRV GND_LOGIC nfet L=0.7U W=10U
Mx3_XMPD_197 OUT x3_lockout GND_DRV GND_LOGIC nfet L=0.7U W=10U
Mx3_XMPD_198 OUT x3_lockout GND_DRV GND_LOGIC nfet L=0.7U W=10U
Mx3_XMPD_199 OUT x3_lockout GND_DRV GND_LOGIC nfet L=0.7U W=10U
Mx3_XMPD_2 OUT x3_lockout GND_DRV GND_LOGIC nfet L=0.7U W=10U
Mx3_XMPD_20 OUT x3_lockout GND_DRV GND_LOGIC nfet L=0.7U W=10U
Mx3_XMPD_200 OUT x3_lockout GND_DRV GND_LOGIC nfet L=0.7U W=10U
Mx3_XMPD_201 OUT x3_lockout GND_DRV GND_LOGIC nfet L=0.7U W=10U
Mx3_XMPD_202 OUT x3_lockout GND_DRV GND_LOGIC nfet L=0.7U W=10U
Mx3_XMPD_203 OUT x3_lockout GND_DRV GND_LOGIC nfet L=0.7U W=10U
Mx3_XMPD_204 OUT x3_lockout GND_DRV GND_LOGIC nfet L=0.7U W=10U
Mx3_XMPD_205 OUT x3_lockout GND_DRV GND_LOGIC nfet L=0.7U W=10U
Mx3_XMPD_206 OUT x3_lockout GND_DRV GND_LOGIC nfet L=0.7U W=10U
Mx3_XMPD_207 OUT x3_lockout GND_DRV GND_LOGIC nfet L=0.7U W=10U
Mx3_XMPD_208 OUT x3_lockout GND_DRV GND_LOGIC nfet L=0.7U W=10U
Mx3_XMPD_209 OUT x3_lockout GND_DRV GND_LOGIC nfet L=0.7U W=10U
Mx3_XMPD_21 OUT x3_lockout GND_DRV GND_LOGIC nfet L=0.7U W=10U
Mx3_XMPD_210 OUT x3_lockout GND_DRV GND_LOGIC nfet L=0.7U W=10U
Mx3_XMPD_211 OUT x3_lockout GND_DRV GND_LOGIC nfet L=0.7U W=10U
Mx3_XMPD_212 OUT x3_lockout GND_DRV GND_LOGIC nfet L=0.7U W=10U
Mx3_XMPD_213 OUT x3_lockout GND_DRV GND_LOGIC nfet L=0.7U W=10U
Mx3_XMPD_214 OUT x3_lockout GND_DRV GND_LOGIC nfet L=0.7U W=10U
Mx3_XMPD_215 OUT x3_lockout GND_DRV GND_LOGIC nfet L=0.7U W=10U
Mx3_XMPD_216 OUT x3_lockout GND_DRV GND_LOGIC nfet L=0.7U W=10U
Mx3_XMPD_217 OUT x3_lockout GND_DRV GND_LOGIC nfet L=0.7U W=10U
Mx3_XMPD_218 OUT x3_lockout GND_DRV GND_LOGIC nfet L=0.7U W=10U
Mx3_XMPD_219 OUT x3_lockout GND_DRV GND_LOGIC nfet L=0.7U W=10U
Mx3_XMPD_22 OUT x3_lockout GND_DRV GND_LOGIC nfet L=0.7U W=10U
Mx3_XMPD_220 OUT x3_lockout GND_DRV GND_LOGIC nfet L=0.7U W=10U
Mx3_XMPD_221 OUT x3_lockout GND_DRV GND_LOGIC nfet L=0.7U W=10U
Mx3_XMPD_222 OUT x3_lockout GND_DRV GND_LOGIC nfet L=0.7U W=10U
Mx3_XMPD_223 OUT x3_lockout GND_DRV GND_LOGIC nfet L=0.7U W=10U
Mx3_XMPD_224 OUT x3_lockout GND_DRV GND_LOGIC nfet L=0.7U W=10U
Mx3_XMPD_225 OUT x3_lockout GND_DRV GND_LOGIC nfet L=0.7U W=10U
Mx3_XMPD_226 OUT x3_lockout GND_DRV GND_LOGIC nfet L=0.7U W=10U
Mx3_XMPD_227 OUT x3_lockout GND_DRV GND_LOGIC nfet L=0.7U W=10U
Mx3_XMPD_228 OUT x3_lockout GND_DRV GND_LOGIC nfet L=0.7U W=10U
Mx3_XMPD_229 OUT x3_lockout GND_DRV GND_LOGIC nfet L=0.7U W=10U
Mx3_XMPD_23 OUT x3_lockout GND_DRV GND_LOGIC nfet L=0.7U W=10U
Mx3_XMPD_230 OUT x3_lockout GND_DRV GND_LOGIC nfet L=0.7U W=10U
Mx3_XMPD_231 OUT x3_lockout GND_DRV GND_LOGIC nfet L=0.7U W=10U
Mx3_XMPD_232 OUT x3_lockout GND_DRV GND_LOGIC nfet L=0.7U W=10U
Mx3_XMPD_233 OUT x3_lockout GND_DRV GND_LOGIC nfet L=0.7U W=10U
Mx3_XMPD_234 OUT x3_lockout GND_DRV GND_LOGIC nfet L=0.7U W=10U
Mx3_XMPD_235 OUT x3_lockout GND_DRV GND_LOGIC nfet L=0.7U W=10U
Mx3_XMPD_236 OUT x3_lockout GND_DRV GND_LOGIC nfet L=0.7U W=10U
Mx3_XMPD_237 OUT x3_lockout GND_DRV GND_LOGIC nfet L=0.7U W=10U
Mx3_XMPD_238 OUT x3_lockout GND_DRV GND_LOGIC nfet L=0.7U W=10U
Mx3_XMPD_239 OUT x3_lockout GND_DRV GND_LOGIC nfet L=0.7U W=10U
Mx3_XMPD_24 OUT x3_lockout GND_DRV GND_LOGIC nfet L=0.7U W=10U
Mx3_XMPD_240 OUT x3_lockout GND_DRV GND_LOGIC nfet L=0.7U W=10U
Mx3_XMPD_241 OUT x3_lockout GND_DRV GND_LOGIC nfet L=0.7U W=10U
Mx3_XMPD_242 OUT x3_lockout GND_DRV GND_LOGIC nfet L=0.7U W=10U
Mx3_XMPD_243 OUT x3_lockout GND_DRV GND_LOGIC nfet L=0.7U W=10U
Mx3_XMPD_244 OUT x3_lockout GND_DRV GND_LOGIC nfet L=0.7U W=10U
Mx3_XMPD_245 OUT x3_lockout GND_DRV GND_LOGIC nfet L=0.7U W=10U
Mx3_XMPD_246 OUT x3_lockout GND_DRV GND_LOGIC nfet L=0.7U W=10U
Mx3_XMPD_247 OUT x3_lockout GND_DRV GND_LOGIC nfet L=0.7U W=10U
Mx3_XMPD_248 OUT x3_lockout GND_DRV GND_LOGIC nfet L=0.7U W=10U
Mx3_XMPD_249 OUT x3_lockout GND_DRV GND_LOGIC nfet L=0.7U W=10U
Mx3_XMPD_25 OUT x3_lockout GND_DRV GND_LOGIC nfet L=0.7U W=10U
Mx3_XMPD_250 OUT x3_lockout GND_DRV GND_LOGIC nfet L=0.7U W=10U
Mx3_XMPD_251 OUT x3_lockout GND_DRV GND_LOGIC nfet L=0.7U W=10U
Mx3_XMPD_252 OUT x3_lockout GND_DRV GND_LOGIC nfet L=0.7U W=10U
Mx3_XMPD_253 OUT x3_lockout GND_DRV GND_LOGIC nfet L=0.7U W=10U
Mx3_XMPD_254 OUT x3_lockout GND_DRV GND_LOGIC nfet L=0.7U W=10U
Mx3_XMPD_255 OUT x3_lockout GND_DRV GND_LOGIC nfet L=0.7U W=10U
Mx3_XMPD_256 OUT x3_lockout GND_DRV GND_LOGIC nfet L=0.7U W=10U
Mx3_XMPD_257 OUT x3_lockout GND_DRV GND_LOGIC nfet L=0.7U W=10U
Mx3_XMPD_258 OUT x3_lockout GND_DRV GND_LOGIC nfet L=0.7U W=10U
Mx3_XMPD_259 OUT x3_lockout GND_DRV GND_LOGIC nfet L=0.7U W=10U
Mx3_XMPD_26 OUT x3_lockout GND_DRV GND_LOGIC nfet L=0.7U W=10U
Mx3_XMPD_260 OUT x3_lockout GND_DRV GND_LOGIC nfet L=0.7U W=10U
Mx3_XMPD_261 OUT x3_lockout GND_DRV GND_LOGIC nfet L=0.7U W=10U
Mx3_XMPD_262 OUT x3_lockout GND_DRV GND_LOGIC nfet L=0.7U W=10U
Mx3_XMPD_263 OUT x3_lockout GND_DRV GND_LOGIC nfet L=0.7U W=10U
Mx3_XMPD_264 OUT x3_lockout GND_DRV GND_LOGIC nfet L=0.7U W=10U
Mx3_XMPD_265 OUT x3_lockout GND_DRV GND_LOGIC nfet L=0.7U W=10U
Mx3_XMPD_266 OUT x3_lockout GND_DRV GND_LOGIC nfet L=0.7U W=10U
Mx3_XMPD_267 OUT x3_lockout GND_DRV GND_LOGIC nfet L=0.7U W=10U
Mx3_XMPD_268 OUT x3_lockout GND_DRV GND_LOGIC nfet L=0.7U W=10U
Mx3_XMPD_269 OUT x3_lockout GND_DRV GND_LOGIC nfet L=0.7U W=10U
Mx3_XMPD_27 OUT x3_lockout GND_DRV GND_LOGIC nfet L=0.7U W=10U
Mx3_XMPD_270 OUT x3_lockout GND_DRV GND_LOGIC nfet L=0.7U W=10U
Mx3_XMPD_271 OUT x3_lockout GND_DRV GND_LOGIC nfet L=0.7U W=10U
Mx3_XMPD_272 OUT x3_lockout GND_DRV GND_LOGIC nfet L=0.7U W=10U
Mx3_XMPD_273 OUT x3_lockout GND_DRV GND_LOGIC nfet L=0.7U W=10U
Mx3_XMPD_274 OUT x3_lockout GND_DRV GND_LOGIC nfet L=0.7U W=10U
Mx3_XMPD_275 OUT x3_lockout GND_DRV GND_LOGIC nfet L=0.7U W=10U
Mx3_XMPD_276 OUT x3_lockout GND_DRV GND_LOGIC nfet L=0.7U W=10U
Mx3_XMPD_277 OUT x3_lockout GND_DRV GND_LOGIC nfet L=0.7U W=10U
Mx3_XMPD_278 OUT x3_lockout GND_DRV GND_LOGIC nfet L=0.7U W=10U
Mx3_XMPD_279 OUT x3_lockout GND_DRV GND_LOGIC nfet L=0.7U W=10U
Mx3_XMPD_28 OUT x3_lockout GND_DRV GND_LOGIC nfet L=0.7U W=10U
Mx3_XMPD_280 OUT x3_lockout GND_DRV GND_LOGIC nfet L=0.7U W=10U
Mx3_XMPD_281 OUT x3_lockout GND_DRV GND_LOGIC nfet L=0.7U W=10U
Mx3_XMPD_282 OUT x3_lockout GND_DRV GND_LOGIC nfet L=0.7U W=10U
Mx3_XMPD_283 OUT x3_lockout GND_DRV GND_LOGIC nfet L=0.7U W=10U
Mx3_XMPD_284 OUT x3_lockout GND_DRV GND_LOGIC nfet L=0.7U W=10U
Mx3_XMPD_285 OUT x3_lockout GND_DRV GND_LOGIC nfet L=0.7U W=10U
Mx3_XMPD_286 OUT x3_lockout GND_DRV GND_LOGIC nfet L=0.7U W=10U
Mx3_XMPD_287 OUT x3_lockout GND_DRV GND_LOGIC nfet L=0.7U W=10U
Mx3_XMPD_288 OUT x3_lockout GND_DRV GND_LOGIC nfet L=0.7U W=10U
Mx3_XMPD_289 OUT x3_lockout GND_DRV GND_LOGIC nfet L=0.7U W=10U
Mx3_XMPD_29 OUT x3_lockout GND_DRV GND_LOGIC nfet L=0.7U W=10U
Mx3_XMPD_290 OUT x3_lockout GND_DRV GND_LOGIC nfet L=0.7U W=10U
Mx3_XMPD_291 OUT x3_lockout GND_DRV GND_LOGIC nfet L=0.7U W=10U
Mx3_XMPD_292 OUT x3_lockout GND_DRV GND_LOGIC nfet L=0.7U W=10U
Mx3_XMPD_293 OUT x3_lockout GND_DRV GND_LOGIC nfet L=0.7U W=10U
Mx3_XMPD_294 OUT x3_lockout GND_DRV GND_LOGIC nfet L=0.7U W=10U
Mx3_XMPD_295 OUT x3_lockout GND_DRV GND_LOGIC nfet L=0.7U W=10U
Mx3_XMPD_296 OUT x3_lockout GND_DRV GND_LOGIC nfet L=0.7U W=10U
Mx3_XMPD_297 OUT x3_lockout GND_DRV GND_LOGIC nfet L=0.7U W=10U
Mx3_XMPD_298 OUT x3_lockout GND_DRV GND_LOGIC nfet L=0.7U W=10U
Mx3_XMPD_299 OUT x3_lockout GND_DRV GND_LOGIC nfet L=0.7U W=10U
Mx3_XMPD_3 OUT x3_lockout GND_DRV GND_LOGIC nfet L=0.7U W=10U
Mx3_XMPD_30 OUT x3_lockout GND_DRV GND_LOGIC nfet L=0.7U W=10U
Mx3_XMPD_300 OUT x3_lockout GND_DRV GND_LOGIC nfet L=0.7U W=10U
Mx3_XMPD_301 OUT x3_lockout GND_DRV GND_LOGIC nfet L=0.7U W=10U
Mx3_XMPD_302 OUT x3_lockout GND_DRV GND_LOGIC nfet L=0.7U W=10U
Mx3_XMPD_303 OUT x3_lockout GND_DRV GND_LOGIC nfet L=0.7U W=10U
Mx3_XMPD_304 OUT x3_lockout GND_DRV GND_LOGIC nfet L=0.7U W=10U
Mx3_XMPD_305 OUT x3_lockout GND_DRV GND_LOGIC nfet L=0.7U W=10U
Mx3_XMPD_306 OUT x3_lockout GND_DRV GND_LOGIC nfet L=0.7U W=10U
Mx3_XMPD_307 OUT x3_lockout GND_DRV GND_LOGIC nfet L=0.7U W=10U
Mx3_XMPD_308 OUT x3_lockout GND_DRV GND_LOGIC nfet L=0.7U W=10U
Mx3_XMPD_309 OUT x3_lockout GND_DRV GND_LOGIC nfet L=0.7U W=10U
Mx3_XMPD_31 OUT x3_lockout GND_DRV GND_LOGIC nfet L=0.7U W=10U
Mx3_XMPD_310 OUT x3_lockout GND_DRV GND_LOGIC nfet L=0.7U W=10U
Mx3_XMPD_311 OUT x3_lockout GND_DRV GND_LOGIC nfet L=0.7U W=10U
Mx3_XMPD_312 OUT x3_lockout GND_DRV GND_LOGIC nfet L=0.7U W=10U
Mx3_XMPD_313 OUT x3_lockout GND_DRV GND_LOGIC nfet L=0.7U W=10U
Mx3_XMPD_314 OUT x3_lockout GND_DRV GND_LOGIC nfet L=0.7U W=10U
Mx3_XMPD_315 OUT x3_lockout GND_DRV GND_LOGIC nfet L=0.7U W=10U
Mx3_XMPD_316 OUT x3_lockout GND_DRV GND_LOGIC nfet L=0.7U W=10U
Mx3_XMPD_317 OUT x3_lockout GND_DRV GND_LOGIC nfet L=0.7U W=10U
Mx3_XMPD_318 OUT x3_lockout GND_DRV GND_LOGIC nfet L=0.7U W=10U
Mx3_XMPD_319 OUT x3_lockout GND_DRV GND_LOGIC nfet L=0.7U W=10U
Mx3_XMPD_32 OUT x3_lockout GND_DRV GND_LOGIC nfet L=0.7U W=10U
Mx3_XMPD_320 OUT x3_lockout GND_DRV GND_LOGIC nfet L=0.7U W=10U
Mx3_XMPD_321 OUT x3_lockout GND_DRV GND_LOGIC nfet L=0.7U W=10U
Mx3_XMPD_322 OUT x3_lockout GND_DRV GND_LOGIC nfet L=0.7U W=10U
Mx3_XMPD_323 OUT x3_lockout GND_DRV GND_LOGIC nfet L=0.7U W=10U
Mx3_XMPD_324 OUT x3_lockout GND_DRV GND_LOGIC nfet L=0.7U W=10U
Mx3_XMPD_325 OUT x3_lockout GND_DRV GND_LOGIC nfet L=0.7U W=10U
Mx3_XMPD_326 OUT x3_lockout GND_DRV GND_LOGIC nfet L=0.7U W=10U
Mx3_XMPD_327 OUT x3_lockout GND_DRV GND_LOGIC nfet L=0.7U W=10U
Mx3_XMPD_328 OUT x3_lockout GND_DRV GND_LOGIC nfet L=0.7U W=10U
Mx3_XMPD_329 OUT x3_lockout GND_DRV GND_LOGIC nfet L=0.7U W=10U
Mx3_XMPD_33 OUT x3_lockout GND_DRV GND_LOGIC nfet L=0.7U W=10U
Mx3_XMPD_330 OUT x3_lockout GND_DRV GND_LOGIC nfet L=0.7U W=10U
Mx3_XMPD_331 OUT x3_lockout GND_DRV GND_LOGIC nfet L=0.7U W=10U
Mx3_XMPD_332 OUT x3_lockout GND_DRV GND_LOGIC nfet L=0.7U W=10U
Mx3_XMPD_333 OUT x3_lockout GND_DRV GND_LOGIC nfet L=0.7U W=10U
Mx3_XMPD_334 OUT x3_lockout GND_DRV GND_LOGIC nfet L=0.7U W=10U
Mx3_XMPD_335 OUT x3_lockout GND_DRV GND_LOGIC nfet L=0.7U W=10U
Mx3_XMPD_336 OUT x3_lockout GND_DRV GND_LOGIC nfet L=0.7U W=10U
Mx3_XMPD_337 OUT x3_lockout GND_DRV GND_LOGIC nfet L=0.7U W=10U
Mx3_XMPD_338 OUT x3_lockout GND_DRV GND_LOGIC nfet L=0.7U W=10U
Mx3_XMPD_339 OUT x3_lockout GND_DRV GND_LOGIC nfet L=0.7U W=10U
Mx3_XMPD_34 OUT x3_lockout GND_DRV GND_LOGIC nfet L=0.7U W=10U
Mx3_XMPD_340 OUT x3_lockout GND_DRV GND_LOGIC nfet L=0.7U W=10U
Mx3_XMPD_341 OUT x3_lockout GND_DRV GND_LOGIC nfet L=0.7U W=10U
Mx3_XMPD_342 OUT x3_lockout GND_DRV GND_LOGIC nfet L=0.7U W=10U
Mx3_XMPD_343 OUT x3_lockout GND_DRV GND_LOGIC nfet L=0.7U W=10U
Mx3_XMPD_344 OUT x3_lockout GND_DRV GND_LOGIC nfet L=0.7U W=10U
Mx3_XMPD_345 OUT x3_lockout GND_DRV GND_LOGIC nfet L=0.7U W=10U
Mx3_XMPD_346 OUT x3_lockout GND_DRV GND_LOGIC nfet L=0.7U W=10U
Mx3_XMPD_347 OUT x3_lockout GND_DRV GND_LOGIC nfet L=0.7U W=10U
Mx3_XMPD_348 OUT x3_lockout GND_DRV GND_LOGIC nfet L=0.7U W=10U
Mx3_XMPD_349 OUT x3_lockout GND_DRV GND_LOGIC nfet L=0.7U W=10U
Mx3_XMPD_35 OUT x3_lockout GND_DRV GND_LOGIC nfet L=0.7U W=10U
Mx3_XMPD_350 OUT x3_lockout GND_DRV GND_LOGIC nfet L=0.7U W=10U
Mx3_XMPD_351 OUT x3_lockout GND_DRV GND_LOGIC nfet L=0.7U W=10U
Mx3_XMPD_352 OUT x3_lockout GND_DRV GND_LOGIC nfet L=0.7U W=10U
Mx3_XMPD_353 OUT x3_lockout GND_DRV GND_LOGIC nfet L=0.7U W=10U
Mx3_XMPD_354 OUT x3_lockout GND_DRV GND_LOGIC nfet L=0.7U W=10U
Mx3_XMPD_355 OUT x3_lockout GND_DRV GND_LOGIC nfet L=0.7U W=10U
Mx3_XMPD_356 OUT x3_lockout GND_DRV GND_LOGIC nfet L=0.7U W=10U
Mx3_XMPD_357 OUT x3_lockout GND_DRV GND_LOGIC nfet L=0.7U W=10U
Mx3_XMPD_358 OUT x3_lockout GND_DRV GND_LOGIC nfet L=0.7U W=10U
Mx3_XMPD_359 OUT x3_lockout GND_DRV GND_LOGIC nfet L=0.7U W=10U
Mx3_XMPD_36 OUT x3_lockout GND_DRV GND_LOGIC nfet L=0.7U W=10U
Mx3_XMPD_360 OUT x3_lockout GND_DRV GND_LOGIC nfet L=0.7U W=10U
Mx3_XMPD_361 OUT x3_lockout GND_DRV GND_LOGIC nfet L=0.7U W=10U
Mx3_XMPD_362 OUT x3_lockout GND_DRV GND_LOGIC nfet L=0.7U W=10U
Mx3_XMPD_363 OUT x3_lockout GND_DRV GND_LOGIC nfet L=0.7U W=10U
Mx3_XMPD_364 OUT x3_lockout GND_DRV GND_LOGIC nfet L=0.7U W=10U
Mx3_XMPD_365 OUT x3_lockout GND_DRV GND_LOGIC nfet L=0.7U W=10U
Mx3_XMPD_366 OUT x3_lockout GND_DRV GND_LOGIC nfet L=0.7U W=10U
Mx3_XMPD_367 OUT x3_lockout GND_DRV GND_LOGIC nfet L=0.7U W=10U
Mx3_XMPD_368 OUT x3_lockout GND_DRV GND_LOGIC nfet L=0.7U W=10U
Mx3_XMPD_369 OUT x3_lockout GND_DRV GND_LOGIC nfet L=0.7U W=10U
Mx3_XMPD_37 OUT x3_lockout GND_DRV GND_LOGIC nfet L=0.7U W=10U
Mx3_XMPD_370 OUT x3_lockout GND_DRV GND_LOGIC nfet L=0.7U W=10U
Mx3_XMPD_371 OUT x3_lockout GND_DRV GND_LOGIC nfet L=0.7U W=10U
Mx3_XMPD_372 OUT x3_lockout GND_DRV GND_LOGIC nfet L=0.7U W=10U
Mx3_XMPD_373 OUT x3_lockout GND_DRV GND_LOGIC nfet L=0.7U W=10U
Mx3_XMPD_374 OUT x3_lockout GND_DRV GND_LOGIC nfet L=0.7U W=10U
Mx3_XMPD_375 OUT x3_lockout GND_DRV GND_LOGIC nfet L=0.7U W=10U
Mx3_XMPD_376 OUT x3_lockout GND_DRV GND_LOGIC nfet L=0.7U W=10U
Mx3_XMPD_377 OUT x3_lockout GND_DRV GND_LOGIC nfet L=0.7U W=10U
Mx3_XMPD_378 OUT x3_lockout GND_DRV GND_LOGIC nfet L=0.7U W=10U
Mx3_XMPD_379 OUT x3_lockout GND_DRV GND_LOGIC nfet L=0.7U W=10U
Mx3_XMPD_38 OUT x3_lockout GND_DRV GND_LOGIC nfet L=0.7U W=10U
Mx3_XMPD_380 OUT x3_lockout GND_DRV GND_LOGIC nfet L=0.7U W=10U
Mx3_XMPD_381 OUT x3_lockout GND_DRV GND_LOGIC nfet L=0.7U W=10U
Mx3_XMPD_382 OUT x3_lockout GND_DRV GND_LOGIC nfet L=0.7U W=10U
Mx3_XMPD_383 OUT x3_lockout GND_DRV GND_LOGIC nfet L=0.7U W=10U
Mx3_XMPD_384 OUT x3_lockout GND_DRV GND_LOGIC nfet L=0.7U W=10U
Mx3_XMPD_385 OUT x3_lockout GND_DRV GND_LOGIC nfet L=0.7U W=10U
Mx3_XMPD_386 OUT x3_lockout GND_DRV GND_LOGIC nfet L=0.7U W=10U
Mx3_XMPD_387 OUT x3_lockout GND_DRV GND_LOGIC nfet L=0.7U W=10U
Mx3_XMPD_388 OUT x3_lockout GND_DRV GND_LOGIC nfet L=0.7U W=10U
Mx3_XMPD_389 OUT x3_lockout GND_DRV GND_LOGIC nfet L=0.7U W=10U
Mx3_XMPD_39 OUT x3_lockout GND_DRV GND_LOGIC nfet L=0.7U W=10U
Mx3_XMPD_390 OUT x3_lockout GND_DRV GND_LOGIC nfet L=0.7U W=10U
Mx3_XMPD_391 OUT x3_lockout GND_DRV GND_LOGIC nfet L=0.7U W=10U
Mx3_XMPD_392 OUT x3_lockout GND_DRV GND_LOGIC nfet L=0.7U W=10U
Mx3_XMPD_393 OUT x3_lockout GND_DRV GND_LOGIC nfet L=0.7U W=10U
Mx3_XMPD_394 OUT x3_lockout GND_DRV GND_LOGIC nfet L=0.7U W=10U
Mx3_XMPD_395 OUT x3_lockout GND_DRV GND_LOGIC nfet L=0.7U W=10U
Mx3_XMPD_396 OUT x3_lockout GND_DRV GND_LOGIC nfet L=0.7U W=10U
Mx3_XMPD_397 OUT x3_lockout GND_DRV GND_LOGIC nfet L=0.7U W=10U
Mx3_XMPD_398 OUT x3_lockout GND_DRV GND_LOGIC nfet L=0.7U W=10U
Mx3_XMPD_399 OUT x3_lockout GND_DRV GND_LOGIC nfet L=0.7U W=10U
Mx3_XMPD_4 OUT x3_lockout GND_DRV GND_LOGIC nfet L=0.7U W=10U
Mx3_XMPD_40 OUT x3_lockout GND_DRV GND_LOGIC nfet L=0.7U W=10U
Mx3_XMPD_400 OUT x3_lockout GND_DRV GND_LOGIC nfet L=0.7U W=10U
Mx3_XMPD_401 OUT x3_lockout GND_DRV GND_LOGIC nfet L=0.7U W=10U
Mx3_XMPD_402 OUT x3_lockout GND_DRV GND_LOGIC nfet L=0.7U W=10U
Mx3_XMPD_403 OUT x3_lockout GND_DRV GND_LOGIC nfet L=0.7U W=10U
Mx3_XMPD_404 OUT x3_lockout GND_DRV GND_LOGIC nfet L=0.7U W=10U
Mx3_XMPD_405 OUT x3_lockout GND_DRV GND_LOGIC nfet L=0.7U W=10U
Mx3_XMPD_406 OUT x3_lockout GND_DRV GND_LOGIC nfet L=0.7U W=10U
Mx3_XMPD_407 OUT x3_lockout GND_DRV GND_LOGIC nfet L=0.7U W=10U
Mx3_XMPD_408 OUT x3_lockout GND_DRV GND_LOGIC nfet L=0.7U W=10U
Mx3_XMPD_409 OUT x3_lockout GND_DRV GND_LOGIC nfet L=0.7U W=10U
Mx3_XMPD_41 OUT x3_lockout GND_DRV GND_LOGIC nfet L=0.7U W=10U
Mx3_XMPD_410 OUT x3_lockout GND_DRV GND_LOGIC nfet L=0.7U W=10U
Mx3_XMPD_411 OUT x3_lockout GND_DRV GND_LOGIC nfet L=0.7U W=10U
Mx3_XMPD_412 OUT x3_lockout GND_DRV GND_LOGIC nfet L=0.7U W=10U
Mx3_XMPD_413 OUT x3_lockout GND_DRV GND_LOGIC nfet L=0.7U W=10U
Mx3_XMPD_414 OUT x3_lockout GND_DRV GND_LOGIC nfet L=0.7U W=10U
Mx3_XMPD_415 OUT x3_lockout GND_DRV GND_LOGIC nfet L=0.7U W=10U
Mx3_XMPD_416 OUT x3_lockout GND_DRV GND_LOGIC nfet L=0.7U W=10U
Mx3_XMPD_417 OUT x3_lockout GND_DRV GND_LOGIC nfet L=0.7U W=10U
Mx3_XMPD_418 OUT x3_lockout GND_DRV GND_LOGIC nfet L=0.7U W=10U
Mx3_XMPD_419 OUT x3_lockout GND_DRV GND_LOGIC nfet L=0.7U W=10U
Mx3_XMPD_42 OUT x3_lockout GND_DRV GND_LOGIC nfet L=0.7U W=10U
Mx3_XMPD_420 OUT x3_lockout GND_DRV GND_LOGIC nfet L=0.7U W=10U
Mx3_XMPD_421 OUT x3_lockout GND_DRV GND_LOGIC nfet L=0.7U W=10U
Mx3_XMPD_422 OUT x3_lockout GND_DRV GND_LOGIC nfet L=0.7U W=10U
Mx3_XMPD_423 OUT x3_lockout GND_DRV GND_LOGIC nfet L=0.7U W=10U
Mx3_XMPD_424 OUT x3_lockout GND_DRV GND_LOGIC nfet L=0.7U W=10U
Mx3_XMPD_425 OUT x3_lockout GND_DRV GND_LOGIC nfet L=0.7U W=10U
Mx3_XMPD_426 OUT x3_lockout GND_DRV GND_LOGIC nfet L=0.7U W=10U
Mx3_XMPD_427 OUT x3_lockout GND_DRV GND_LOGIC nfet L=0.7U W=10U
Mx3_XMPD_428 OUT x3_lockout GND_DRV GND_LOGIC nfet L=0.7U W=10U
Mx3_XMPD_429 OUT x3_lockout GND_DRV GND_LOGIC nfet L=0.7U W=10U
Mx3_XMPD_43 OUT x3_lockout GND_DRV GND_LOGIC nfet L=0.7U W=10U
Mx3_XMPD_430 OUT x3_lockout GND_DRV GND_LOGIC nfet L=0.7U W=10U
Mx3_XMPD_431 OUT x3_lockout GND_DRV GND_LOGIC nfet L=0.7U W=10U
Mx3_XMPD_432 OUT x3_lockout GND_DRV GND_LOGIC nfet L=0.7U W=10U
Mx3_XMPD_433 OUT x3_lockout GND_DRV GND_LOGIC nfet L=0.7U W=10U
Mx3_XMPD_434 OUT x3_lockout GND_DRV GND_LOGIC nfet L=0.7U W=10U
Mx3_XMPD_435 OUT x3_lockout GND_DRV GND_LOGIC nfet L=0.7U W=10U
Mx3_XMPD_436 OUT x3_lockout GND_DRV GND_LOGIC nfet L=0.7U W=10U
Mx3_XMPD_437 OUT x3_lockout GND_DRV GND_LOGIC nfet L=0.7U W=10U
Mx3_XMPD_438 OUT x3_lockout GND_DRV GND_LOGIC nfet L=0.7U W=10U
Mx3_XMPD_439 OUT x3_lockout GND_DRV GND_LOGIC nfet L=0.7U W=10U
Mx3_XMPD_44 OUT x3_lockout GND_DRV GND_LOGIC nfet L=0.7U W=10U
Mx3_XMPD_440 OUT x3_lockout GND_DRV GND_LOGIC nfet L=0.7U W=10U
Mx3_XMPD_441 OUT x3_lockout GND_DRV GND_LOGIC nfet L=0.7U W=10U
Mx3_XMPD_442 OUT x3_lockout GND_DRV GND_LOGIC nfet L=0.7U W=10U
Mx3_XMPD_443 OUT x3_lockout GND_DRV GND_LOGIC nfet L=0.7U W=10U
Mx3_XMPD_444 OUT x3_lockout GND_DRV GND_LOGIC nfet L=0.7U W=10U
Mx3_XMPD_445 OUT x3_lockout GND_DRV GND_LOGIC nfet L=0.7U W=10U
Mx3_XMPD_446 OUT x3_lockout GND_DRV GND_LOGIC nfet L=0.7U W=10U
Mx3_XMPD_447 OUT x3_lockout GND_DRV GND_LOGIC nfet L=0.7U W=10U
Mx3_XMPD_448 OUT x3_lockout GND_DRV GND_LOGIC nfet L=0.7U W=10U
Mx3_XMPD_449 OUT x3_lockout GND_DRV GND_LOGIC nfet L=0.7U W=10U
Mx3_XMPD_45 OUT x3_lockout GND_DRV GND_LOGIC nfet L=0.7U W=10U
Mx3_XMPD_450 OUT x3_lockout GND_DRV GND_LOGIC nfet L=0.7U W=10U
Mx3_XMPD_451 OUT x3_lockout GND_DRV GND_LOGIC nfet L=0.7U W=10U
Mx3_XMPD_452 OUT x3_lockout GND_DRV GND_LOGIC nfet L=0.7U W=10U
Mx3_XMPD_453 OUT x3_lockout GND_DRV GND_LOGIC nfet L=0.7U W=10U
Mx3_XMPD_454 OUT x3_lockout GND_DRV GND_LOGIC nfet L=0.7U W=10U
Mx3_XMPD_455 OUT x3_lockout GND_DRV GND_LOGIC nfet L=0.7U W=10U
Mx3_XMPD_456 OUT x3_lockout GND_DRV GND_LOGIC nfet L=0.7U W=10U
Mx3_XMPD_457 OUT x3_lockout GND_DRV GND_LOGIC nfet L=0.7U W=10U
Mx3_XMPD_458 OUT x3_lockout GND_DRV GND_LOGIC nfet L=0.7U W=10U
Mx3_XMPD_459 OUT x3_lockout GND_DRV GND_LOGIC nfet L=0.7U W=10U
Mx3_XMPD_46 OUT x3_lockout GND_DRV GND_LOGIC nfet L=0.7U W=10U
Mx3_XMPD_460 OUT x3_lockout GND_DRV GND_LOGIC nfet L=0.7U W=10U
Mx3_XMPD_461 OUT x3_lockout GND_DRV GND_LOGIC nfet L=0.7U W=10U
Mx3_XMPD_462 OUT x3_lockout GND_DRV GND_LOGIC nfet L=0.7U W=10U
Mx3_XMPD_463 OUT x3_lockout GND_DRV GND_LOGIC nfet L=0.7U W=10U
Mx3_XMPD_464 OUT x3_lockout GND_DRV GND_LOGIC nfet L=0.7U W=10U
Mx3_XMPD_465 OUT x3_lockout GND_DRV GND_LOGIC nfet L=0.7U W=10U
Mx3_XMPD_466 OUT x3_lockout GND_DRV GND_LOGIC nfet L=0.7U W=10U
Mx3_XMPD_467 OUT x3_lockout GND_DRV GND_LOGIC nfet L=0.7U W=10U
Mx3_XMPD_468 OUT x3_lockout GND_DRV GND_LOGIC nfet L=0.7U W=10U
Mx3_XMPD_469 OUT x3_lockout GND_DRV GND_LOGIC nfet L=0.7U W=10U
Mx3_XMPD_47 OUT x3_lockout GND_DRV GND_LOGIC nfet L=0.7U W=10U
Mx3_XMPD_470 OUT x3_lockout GND_DRV GND_LOGIC nfet L=0.7U W=10U
Mx3_XMPD_471 OUT x3_lockout GND_DRV GND_LOGIC nfet L=0.7U W=10U
Mx3_XMPD_472 OUT x3_lockout GND_DRV GND_LOGIC nfet L=0.7U W=10U
Mx3_XMPD_473 OUT x3_lockout GND_DRV GND_LOGIC nfet L=0.7U W=10U
Mx3_XMPD_474 OUT x3_lockout GND_DRV GND_LOGIC nfet L=0.7U W=10U
Mx3_XMPD_475 OUT x3_lockout GND_DRV GND_LOGIC nfet L=0.7U W=10U
Mx3_XMPD_476 OUT x3_lockout GND_DRV GND_LOGIC nfet L=0.7U W=10U
Mx3_XMPD_477 OUT x3_lockout GND_DRV GND_LOGIC nfet L=0.7U W=10U
Mx3_XMPD_478 OUT x3_lockout GND_DRV GND_LOGIC nfet L=0.7U W=10U
Mx3_XMPD_479 OUT x3_lockout GND_DRV GND_LOGIC nfet L=0.7U W=10U
Mx3_XMPD_48 OUT x3_lockout GND_DRV GND_LOGIC nfet L=0.7U W=10U
Mx3_XMPD_480 OUT x3_lockout GND_DRV GND_LOGIC nfet L=0.7U W=10U
Mx3_XMPD_481 OUT x3_lockout GND_DRV GND_LOGIC nfet L=0.7U W=10U
Mx3_XMPD_482 OUT x3_lockout GND_DRV GND_LOGIC nfet L=0.7U W=10U
Mx3_XMPD_483 OUT x3_lockout GND_DRV GND_LOGIC nfet L=0.7U W=10U
Mx3_XMPD_484 OUT x3_lockout GND_DRV GND_LOGIC nfet L=0.7U W=10U
Mx3_XMPD_485 OUT x3_lockout GND_DRV GND_LOGIC nfet L=0.7U W=10U
Mx3_XMPD_486 OUT x3_lockout GND_DRV GND_LOGIC nfet L=0.7U W=10U
Mx3_XMPD_487 OUT x3_lockout GND_DRV GND_LOGIC nfet L=0.7U W=10U
Mx3_XMPD_488 OUT x3_lockout GND_DRV GND_LOGIC nfet L=0.7U W=10U
Mx3_XMPD_489 OUT x3_lockout GND_DRV GND_LOGIC nfet L=0.7U W=10U
Mx3_XMPD_49 OUT x3_lockout GND_DRV GND_LOGIC nfet L=0.7U W=10U
Mx3_XMPD_490 OUT x3_lockout GND_DRV GND_LOGIC nfet L=0.7U W=10U
Mx3_XMPD_491 OUT x3_lockout GND_DRV GND_LOGIC nfet L=0.7U W=10U
Mx3_XMPD_492 OUT x3_lockout GND_DRV GND_LOGIC nfet L=0.7U W=10U
Mx3_XMPD_493 OUT x3_lockout GND_DRV GND_LOGIC nfet L=0.7U W=10U
Mx3_XMPD_494 OUT x3_lockout GND_DRV GND_LOGIC nfet L=0.7U W=10U
Mx3_XMPD_495 OUT x3_lockout GND_DRV GND_LOGIC nfet L=0.7U W=10U
Mx3_XMPD_496 OUT x3_lockout GND_DRV GND_LOGIC nfet L=0.7U W=10U
Mx3_XMPD_497 OUT x3_lockout GND_DRV GND_LOGIC nfet L=0.7U W=10U
Mx3_XMPD_498 OUT x3_lockout GND_DRV GND_LOGIC nfet L=0.7U W=10U
Mx3_XMPD_499 OUT x3_lockout GND_DRV GND_LOGIC nfet L=0.7U W=10U
Mx3_XMPD_5 OUT x3_lockout GND_DRV GND_LOGIC nfet L=0.7U W=10U
Mx3_XMPD_50 OUT x3_lockout GND_DRV GND_LOGIC nfet L=0.7U W=10U
Mx3_XMPD_500 OUT x3_lockout GND_DRV GND_LOGIC nfet L=0.7U W=10U
Mx3_XMPD_501 OUT x3_lockout GND_DRV GND_LOGIC nfet L=0.7U W=10U
Mx3_XMPD_502 OUT x3_lockout GND_DRV GND_LOGIC nfet L=0.7U W=10U
Mx3_XMPD_503 OUT x3_lockout GND_DRV GND_LOGIC nfet L=0.7U W=10U
Mx3_XMPD_504 OUT x3_lockout GND_DRV GND_LOGIC nfet L=0.7U W=10U
Mx3_XMPD_505 OUT x3_lockout GND_DRV GND_LOGIC nfet L=0.7U W=10U
Mx3_XMPD_506 OUT x3_lockout GND_DRV GND_LOGIC nfet L=0.7U W=10U
Mx3_XMPD_507 OUT x3_lockout GND_DRV GND_LOGIC nfet L=0.7U W=10U
Mx3_XMPD_508 OUT x3_lockout GND_DRV GND_LOGIC nfet L=0.7U W=10U
Mx3_XMPD_509 OUT x3_lockout GND_DRV GND_LOGIC nfet L=0.7U W=10U
Mx3_XMPD_51 OUT x3_lockout GND_DRV GND_LOGIC nfet L=0.7U W=10U
Mx3_XMPD_510 OUT x3_lockout GND_DRV GND_LOGIC nfet L=0.7U W=10U
Mx3_XMPD_511 OUT x3_lockout GND_DRV GND_LOGIC nfet L=0.7U W=10U
Mx3_XMPD_512 OUT x3_lockout GND_DRV GND_LOGIC nfet L=0.7U W=10U
Mx3_XMPD_513 OUT x3_lockout GND_DRV GND_LOGIC nfet L=0.7U W=10U
Mx3_XMPD_514 OUT x3_lockout GND_DRV GND_LOGIC nfet L=0.7U W=10U
Mx3_XMPD_515 OUT x3_lockout GND_DRV GND_LOGIC nfet L=0.7U W=10U
Mx3_XMPD_516 OUT x3_lockout GND_DRV GND_LOGIC nfet L=0.7U W=10U
Mx3_XMPD_517 OUT x3_lockout GND_DRV GND_LOGIC nfet L=0.7U W=10U
Mx3_XMPD_518 OUT x3_lockout GND_DRV GND_LOGIC nfet L=0.7U W=10U
Mx3_XMPD_519 OUT x3_lockout GND_DRV GND_LOGIC nfet L=0.7U W=10U
Mx3_XMPD_52 OUT x3_lockout GND_DRV GND_LOGIC nfet L=0.7U W=10U
Mx3_XMPD_520 OUT x3_lockout GND_DRV GND_LOGIC nfet L=0.7U W=10U
Mx3_XMPD_521 OUT x3_lockout GND_DRV GND_LOGIC nfet L=0.7U W=10U
Mx3_XMPD_522 OUT x3_lockout GND_DRV GND_LOGIC nfet L=0.7U W=10U
Mx3_XMPD_523 OUT x3_lockout GND_DRV GND_LOGIC nfet L=0.7U W=10U
Mx3_XMPD_524 OUT x3_lockout GND_DRV GND_LOGIC nfet L=0.7U W=10U
Mx3_XMPD_525 OUT x3_lockout GND_DRV GND_LOGIC nfet L=0.7U W=10U
Mx3_XMPD_526 OUT x3_lockout GND_DRV GND_LOGIC nfet L=0.7U W=10U
Mx3_XMPD_527 OUT x3_lockout GND_DRV GND_LOGIC nfet L=0.7U W=10U
Mx3_XMPD_528 OUT x3_lockout GND_DRV GND_LOGIC nfet L=0.7U W=10U
Mx3_XMPD_529 OUT x3_lockout GND_DRV GND_LOGIC nfet L=0.7U W=10U
Mx3_XMPD_53 OUT x3_lockout GND_DRV GND_LOGIC nfet L=0.7U W=10U
Mx3_XMPD_530 OUT x3_lockout GND_DRV GND_LOGIC nfet L=0.7U W=10U
Mx3_XMPD_531 OUT x3_lockout GND_DRV GND_LOGIC nfet L=0.7U W=10U
Mx3_XMPD_532 OUT x3_lockout GND_DRV GND_LOGIC nfet L=0.7U W=10U
Mx3_XMPD_533 OUT x3_lockout GND_DRV GND_LOGIC nfet L=0.7U W=10U
Mx3_XMPD_534 OUT x3_lockout GND_DRV GND_LOGIC nfet L=0.7U W=10U
Mx3_XMPD_535 OUT x3_lockout GND_DRV GND_LOGIC nfet L=0.7U W=10U
Mx3_XMPD_536 OUT x3_lockout GND_DRV GND_LOGIC nfet L=0.7U W=10U
Mx3_XMPD_537 OUT x3_lockout GND_DRV GND_LOGIC nfet L=0.7U W=10U
Mx3_XMPD_538 OUT x3_lockout GND_DRV GND_LOGIC nfet L=0.7U W=10U
Mx3_XMPD_539 OUT x3_lockout GND_DRV GND_LOGIC nfet L=0.7U W=10U
Mx3_XMPD_54 OUT x3_lockout GND_DRV GND_LOGIC nfet L=0.7U W=10U
Mx3_XMPD_540 OUT x3_lockout GND_DRV GND_LOGIC nfet L=0.7U W=10U
Mx3_XMPD_541 OUT x3_lockout GND_DRV GND_LOGIC nfet L=0.7U W=10U
Mx3_XMPD_542 OUT x3_lockout GND_DRV GND_LOGIC nfet L=0.7U W=10U
Mx3_XMPD_543 OUT x3_lockout GND_DRV GND_LOGIC nfet L=0.7U W=10U
Mx3_XMPD_544 OUT x3_lockout GND_DRV GND_LOGIC nfet L=0.7U W=10U
Mx3_XMPD_545 OUT x3_lockout GND_DRV GND_LOGIC nfet L=0.7U W=10U
Mx3_XMPD_546 OUT x3_lockout GND_DRV GND_LOGIC nfet L=0.7U W=10U
Mx3_XMPD_547 OUT x3_lockout GND_DRV GND_LOGIC nfet L=0.7U W=10U
Mx3_XMPD_548 OUT x3_lockout GND_DRV GND_LOGIC nfet L=0.7U W=10U
Mx3_XMPD_549 OUT x3_lockout GND_DRV GND_LOGIC nfet L=0.7U W=10U
Mx3_XMPD_55 OUT x3_lockout GND_DRV GND_LOGIC nfet L=0.7U W=10U
Mx3_XMPD_550 OUT x3_lockout GND_DRV GND_LOGIC nfet L=0.7U W=10U
Mx3_XMPD_551 OUT x3_lockout GND_DRV GND_LOGIC nfet L=0.7U W=10U
Mx3_XMPD_552 OUT x3_lockout GND_DRV GND_LOGIC nfet L=0.7U W=10U
Mx3_XMPD_553 OUT x3_lockout GND_DRV GND_LOGIC nfet L=0.7U W=10U
Mx3_XMPD_554 OUT x3_lockout GND_DRV GND_LOGIC nfet L=0.7U W=10U
Mx3_XMPD_555 OUT x3_lockout GND_DRV GND_LOGIC nfet L=0.7U W=10U
Mx3_XMPD_556 OUT x3_lockout GND_DRV GND_LOGIC nfet L=0.7U W=10U
Mx3_XMPD_557 OUT x3_lockout GND_DRV GND_LOGIC nfet L=0.7U W=10U
Mx3_XMPD_558 OUT x3_lockout GND_DRV GND_LOGIC nfet L=0.7U W=10U
Mx3_XMPD_559 OUT x3_lockout GND_DRV GND_LOGIC nfet L=0.7U W=10U
Mx3_XMPD_56 OUT x3_lockout GND_DRV GND_LOGIC nfet L=0.7U W=10U
Mx3_XMPD_560 OUT x3_lockout GND_DRV GND_LOGIC nfet L=0.7U W=10U
Mx3_XMPD_561 OUT x3_lockout GND_DRV GND_LOGIC nfet L=0.7U W=10U
Mx3_XMPD_562 OUT x3_lockout GND_DRV GND_LOGIC nfet L=0.7U W=10U
Mx3_XMPD_563 OUT x3_lockout GND_DRV GND_LOGIC nfet L=0.7U W=10U
Mx3_XMPD_564 OUT x3_lockout GND_DRV GND_LOGIC nfet L=0.7U W=10U
Mx3_XMPD_565 OUT x3_lockout GND_DRV GND_LOGIC nfet L=0.7U W=10U
Mx3_XMPD_566 OUT x3_lockout GND_DRV GND_LOGIC nfet L=0.7U W=10U
Mx3_XMPD_567 OUT x3_lockout GND_DRV GND_LOGIC nfet L=0.7U W=10U
Mx3_XMPD_568 OUT x3_lockout GND_DRV GND_LOGIC nfet L=0.7U W=10U
Mx3_XMPD_569 OUT x3_lockout GND_DRV GND_LOGIC nfet L=0.7U W=10U
Mx3_XMPD_57 OUT x3_lockout GND_DRV GND_LOGIC nfet L=0.7U W=10U
Mx3_XMPD_570 OUT x3_lockout GND_DRV GND_LOGIC nfet L=0.7U W=10U
Mx3_XMPD_571 OUT x3_lockout GND_DRV GND_LOGIC nfet L=0.7U W=10U
Mx3_XMPD_572 OUT x3_lockout GND_DRV GND_LOGIC nfet L=0.7U W=10U
Mx3_XMPD_573 OUT x3_lockout GND_DRV GND_LOGIC nfet L=0.7U W=10U
Mx3_XMPD_574 OUT x3_lockout GND_DRV GND_LOGIC nfet L=0.7U W=10U
Mx3_XMPD_575 OUT x3_lockout GND_DRV GND_LOGIC nfet L=0.7U W=10U
Mx3_XMPD_576 OUT x3_lockout GND_DRV GND_LOGIC nfet L=0.7U W=10U
Mx3_XMPD_577 OUT x3_lockout GND_DRV GND_LOGIC nfet L=0.7U W=10U
Mx3_XMPD_578 OUT x3_lockout GND_DRV GND_LOGIC nfet L=0.7U W=10U
Mx3_XMPD_579 OUT x3_lockout GND_DRV GND_LOGIC nfet L=0.7U W=10U
Mx3_XMPD_58 OUT x3_lockout GND_DRV GND_LOGIC nfet L=0.7U W=10U
Mx3_XMPD_580 OUT x3_lockout GND_DRV GND_LOGIC nfet L=0.7U W=10U
Mx3_XMPD_581 OUT x3_lockout GND_DRV GND_LOGIC nfet L=0.7U W=10U
Mx3_XMPD_582 OUT x3_lockout GND_DRV GND_LOGIC nfet L=0.7U W=10U
Mx3_XMPD_583 OUT x3_lockout GND_DRV GND_LOGIC nfet L=0.7U W=10U
Mx3_XMPD_584 OUT x3_lockout GND_DRV GND_LOGIC nfet L=0.7U W=10U
Mx3_XMPD_585 OUT x3_lockout GND_DRV GND_LOGIC nfet L=0.7U W=10U
Mx3_XMPD_586 OUT x3_lockout GND_DRV GND_LOGIC nfet L=0.7U W=10U
Mx3_XMPD_587 OUT x3_lockout GND_DRV GND_LOGIC nfet L=0.7U W=10U
Mx3_XMPD_588 OUT x3_lockout GND_DRV GND_LOGIC nfet L=0.7U W=10U
Mx3_XMPD_589 OUT x3_lockout GND_DRV GND_LOGIC nfet L=0.7U W=10U
Mx3_XMPD_59 OUT x3_lockout GND_DRV GND_LOGIC nfet L=0.7U W=10U
Mx3_XMPD_590 OUT x3_lockout GND_DRV GND_LOGIC nfet L=0.7U W=10U
Mx3_XMPD_591 OUT x3_lockout GND_DRV GND_LOGIC nfet L=0.7U W=10U
Mx3_XMPD_592 OUT x3_lockout GND_DRV GND_LOGIC nfet L=0.7U W=10U
Mx3_XMPD_593 OUT x3_lockout GND_DRV GND_LOGIC nfet L=0.7U W=10U
Mx3_XMPD_594 OUT x3_lockout GND_DRV GND_LOGIC nfet L=0.7U W=10U
Mx3_XMPD_595 OUT x3_lockout GND_DRV GND_LOGIC nfet L=0.7U W=10U
Mx3_XMPD_596 OUT x3_lockout GND_DRV GND_LOGIC nfet L=0.7U W=10U
Mx3_XMPD_597 OUT x3_lockout GND_DRV GND_LOGIC nfet L=0.7U W=10U
Mx3_XMPD_598 OUT x3_lockout GND_DRV GND_LOGIC nfet L=0.7U W=10U
Mx3_XMPD_599 OUT x3_lockout GND_DRV GND_LOGIC nfet L=0.7U W=10U
Mx3_XMPD_6 OUT x3_lockout GND_DRV GND_LOGIC nfet L=0.7U W=10U
Mx3_XMPD_60 OUT x3_lockout GND_DRV GND_LOGIC nfet L=0.7U W=10U
Mx3_XMPD_600 OUT x3_lockout GND_DRV GND_LOGIC nfet L=0.7U W=10U
Mx3_XMPD_601 OUT x3_lockout GND_DRV GND_LOGIC nfet L=0.7U W=10U
Mx3_XMPD_602 OUT x3_lockout GND_DRV GND_LOGIC nfet L=0.7U W=10U
Mx3_XMPD_603 OUT x3_lockout GND_DRV GND_LOGIC nfet L=0.7U W=10U
Mx3_XMPD_604 OUT x3_lockout GND_DRV GND_LOGIC nfet L=0.7U W=10U
Mx3_XMPD_605 OUT x3_lockout GND_DRV GND_LOGIC nfet L=0.7U W=10U
Mx3_XMPD_606 OUT x3_lockout GND_DRV GND_LOGIC nfet L=0.7U W=10U
Mx3_XMPD_607 OUT x3_lockout GND_DRV GND_LOGIC nfet L=0.7U W=10U
Mx3_XMPD_608 OUT x3_lockout GND_DRV GND_LOGIC nfet L=0.7U W=10U
Mx3_XMPD_609 OUT x3_lockout GND_DRV GND_LOGIC nfet L=0.7U W=10U
Mx3_XMPD_61 OUT x3_lockout GND_DRV GND_LOGIC nfet L=0.7U W=10U
Mx3_XMPD_610 OUT x3_lockout GND_DRV GND_LOGIC nfet L=0.7U W=10U
Mx3_XMPD_611 OUT x3_lockout GND_DRV GND_LOGIC nfet L=0.7U W=10U
Mx3_XMPD_612 OUT x3_lockout GND_DRV GND_LOGIC nfet L=0.7U W=10U
Mx3_XMPD_613 OUT x3_lockout GND_DRV GND_LOGIC nfet L=0.7U W=10U
Mx3_XMPD_614 OUT x3_lockout GND_DRV GND_LOGIC nfet L=0.7U W=10U
Mx3_XMPD_615 OUT x3_lockout GND_DRV GND_LOGIC nfet L=0.7U W=10U
Mx3_XMPD_616 OUT x3_lockout GND_DRV GND_LOGIC nfet L=0.7U W=10U
Mx3_XMPD_617 OUT x3_lockout GND_DRV GND_LOGIC nfet L=0.7U W=10U
Mx3_XMPD_618 OUT x3_lockout GND_DRV GND_LOGIC nfet L=0.7U W=10U
Mx3_XMPD_619 OUT x3_lockout GND_DRV GND_LOGIC nfet L=0.7U W=10U
Mx3_XMPD_62 OUT x3_lockout GND_DRV GND_LOGIC nfet L=0.7U W=10U
Mx3_XMPD_620 OUT x3_lockout GND_DRV GND_LOGIC nfet L=0.7U W=10U
Mx3_XMPD_621 OUT x3_lockout GND_DRV GND_LOGIC nfet L=0.7U W=10U
Mx3_XMPD_622 OUT x3_lockout GND_DRV GND_LOGIC nfet L=0.7U W=10U
Mx3_XMPD_623 OUT x3_lockout GND_DRV GND_LOGIC nfet L=0.7U W=10U
Mx3_XMPD_624 OUT x3_lockout GND_DRV GND_LOGIC nfet L=0.7U W=10U
Mx3_XMPD_625 OUT x3_lockout GND_DRV GND_LOGIC nfet L=0.7U W=10U
Mx3_XMPD_626 OUT x3_lockout GND_DRV GND_LOGIC nfet L=0.7U W=10U
Mx3_XMPD_627 OUT x3_lockout GND_DRV GND_LOGIC nfet L=0.7U W=10U
Mx3_XMPD_628 OUT x3_lockout GND_DRV GND_LOGIC nfet L=0.7U W=10U
Mx3_XMPD_629 OUT x3_lockout GND_DRV GND_LOGIC nfet L=0.7U W=10U
Mx3_XMPD_63 OUT x3_lockout GND_DRV GND_LOGIC nfet L=0.7U W=10U
Mx3_XMPD_630 OUT x3_lockout GND_DRV GND_LOGIC nfet L=0.7U W=10U
Mx3_XMPD_631 OUT x3_lockout GND_DRV GND_LOGIC nfet L=0.7U W=10U
Mx3_XMPD_632 OUT x3_lockout GND_DRV GND_LOGIC nfet L=0.7U W=10U
Mx3_XMPD_633 OUT x3_lockout GND_DRV GND_LOGIC nfet L=0.7U W=10U
Mx3_XMPD_634 OUT x3_lockout GND_DRV GND_LOGIC nfet L=0.7U W=10U
Mx3_XMPD_635 OUT x3_lockout GND_DRV GND_LOGIC nfet L=0.7U W=10U
Mx3_XMPD_636 OUT x3_lockout GND_DRV GND_LOGIC nfet L=0.7U W=10U
Mx3_XMPD_637 OUT x3_lockout GND_DRV GND_LOGIC nfet L=0.7U W=10U
Mx3_XMPD_638 OUT x3_lockout GND_DRV GND_LOGIC nfet L=0.7U W=10U
Mx3_XMPD_639 OUT x3_lockout GND_DRV GND_LOGIC nfet L=0.7U W=10U
Mx3_XMPD_64 OUT x3_lockout GND_DRV GND_LOGIC nfet L=0.7U W=10U
Mx3_XMPD_640 OUT x3_lockout GND_DRV GND_LOGIC nfet L=0.7U W=10U
Mx3_XMPD_641 OUT x3_lockout GND_DRV GND_LOGIC nfet L=0.7U W=10U
Mx3_XMPD_642 OUT x3_lockout GND_DRV GND_LOGIC nfet L=0.7U W=10U
Mx3_XMPD_643 OUT x3_lockout GND_DRV GND_LOGIC nfet L=0.7U W=10U
Mx3_XMPD_644 OUT x3_lockout GND_DRV GND_LOGIC nfet L=0.7U W=10U
Mx3_XMPD_645 OUT x3_lockout GND_DRV GND_LOGIC nfet L=0.7U W=10U
Mx3_XMPD_646 OUT x3_lockout GND_DRV GND_LOGIC nfet L=0.7U W=10U
Mx3_XMPD_647 OUT x3_lockout GND_DRV GND_LOGIC nfet L=0.7U W=10U
Mx3_XMPD_648 OUT x3_lockout GND_DRV GND_LOGIC nfet L=0.7U W=10U
Mx3_XMPD_649 OUT x3_lockout GND_DRV GND_LOGIC nfet L=0.7U W=10U
Mx3_XMPD_65 OUT x3_lockout GND_DRV GND_LOGIC nfet L=0.7U W=10U
Mx3_XMPD_650 OUT x3_lockout GND_DRV GND_LOGIC nfet L=0.7U W=10U
Mx3_XMPD_651 OUT x3_lockout GND_DRV GND_LOGIC nfet L=0.7U W=10U
Mx3_XMPD_652 OUT x3_lockout GND_DRV GND_LOGIC nfet L=0.7U W=10U
Mx3_XMPD_653 OUT x3_lockout GND_DRV GND_LOGIC nfet L=0.7U W=10U
Mx3_XMPD_654 OUT x3_lockout GND_DRV GND_LOGIC nfet L=0.7U W=10U
Mx3_XMPD_655 OUT x3_lockout GND_DRV GND_LOGIC nfet L=0.7U W=10U
Mx3_XMPD_656 OUT x3_lockout GND_DRV GND_LOGIC nfet L=0.7U W=10U
Mx3_XMPD_657 OUT x3_lockout GND_DRV GND_LOGIC nfet L=0.7U W=10U
Mx3_XMPD_658 OUT x3_lockout GND_DRV GND_LOGIC nfet L=0.7U W=10U
Mx3_XMPD_659 OUT x3_lockout GND_DRV GND_LOGIC nfet L=0.7U W=10U
Mx3_XMPD_66 OUT x3_lockout GND_DRV GND_LOGIC nfet L=0.7U W=10U
Mx3_XMPD_660 OUT x3_lockout GND_DRV GND_LOGIC nfet L=0.7U W=10U
Mx3_XMPD_661 OUT x3_lockout GND_DRV GND_LOGIC nfet L=0.7U W=10U
Mx3_XMPD_662 OUT x3_lockout GND_DRV GND_LOGIC nfet L=0.7U W=10U
Mx3_XMPD_663 OUT x3_lockout GND_DRV GND_LOGIC nfet L=0.7U W=10U
Mx3_XMPD_664 OUT x3_lockout GND_DRV GND_LOGIC nfet L=0.7U W=10U
Mx3_XMPD_665 OUT x3_lockout GND_DRV GND_LOGIC nfet L=0.7U W=10U
Mx3_XMPD_666 OUT x3_lockout GND_DRV GND_LOGIC nfet L=0.7U W=10U
Mx3_XMPD_667 OUT x3_lockout GND_DRV GND_LOGIC nfet L=0.7U W=10U
Mx3_XMPD_668 OUT x3_lockout GND_DRV GND_LOGIC nfet L=0.7U W=10U
Mx3_XMPD_669 OUT x3_lockout GND_DRV GND_LOGIC nfet L=0.7U W=10U
Mx3_XMPD_67 OUT x3_lockout GND_DRV GND_LOGIC nfet L=0.7U W=10U
Mx3_XMPD_670 OUT x3_lockout GND_DRV GND_LOGIC nfet L=0.7U W=10U
Mx3_XMPD_671 OUT x3_lockout GND_DRV GND_LOGIC nfet L=0.7U W=10U
Mx3_XMPD_672 OUT x3_lockout GND_DRV GND_LOGIC nfet L=0.7U W=10U
Mx3_XMPD_673 OUT x3_lockout GND_DRV GND_LOGIC nfet L=0.7U W=10U
Mx3_XMPD_674 OUT x3_lockout GND_DRV GND_LOGIC nfet L=0.7U W=10U
Mx3_XMPD_675 OUT x3_lockout GND_DRV GND_LOGIC nfet L=0.7U W=10U
Mx3_XMPD_676 OUT x3_lockout GND_DRV GND_LOGIC nfet L=0.7U W=10U
Mx3_XMPD_677 OUT x3_lockout GND_DRV GND_LOGIC nfet L=0.7U W=10U
Mx3_XMPD_678 OUT x3_lockout GND_DRV GND_LOGIC nfet L=0.7U W=10U
Mx3_XMPD_679 OUT x3_lockout GND_DRV GND_LOGIC nfet L=0.7U W=10U
Mx3_XMPD_68 OUT x3_lockout GND_DRV GND_LOGIC nfet L=0.7U W=10U
Mx3_XMPD_680 OUT x3_lockout GND_DRV GND_LOGIC nfet L=0.7U W=10U
Mx3_XMPD_681 OUT x3_lockout GND_DRV GND_LOGIC nfet L=0.7U W=10U
Mx3_XMPD_682 OUT x3_lockout GND_DRV GND_LOGIC nfet L=0.7U W=10U
Mx3_XMPD_683 OUT x3_lockout GND_DRV GND_LOGIC nfet L=0.7U W=10U
Mx3_XMPD_684 OUT x3_lockout GND_DRV GND_LOGIC nfet L=0.7U W=10U
Mx3_XMPD_685 OUT x3_lockout GND_DRV GND_LOGIC nfet L=0.7U W=10U
Mx3_XMPD_686 OUT x3_lockout GND_DRV GND_LOGIC nfet L=0.7U W=10U
Mx3_XMPD_687 OUT x3_lockout GND_DRV GND_LOGIC nfet L=0.7U W=10U
Mx3_XMPD_688 OUT x3_lockout GND_DRV GND_LOGIC nfet L=0.7U W=10U
Mx3_XMPD_689 OUT x3_lockout GND_DRV GND_LOGIC nfet L=0.7U W=10U
Mx3_XMPD_69 OUT x3_lockout GND_DRV GND_LOGIC nfet L=0.7U W=10U
Mx3_XMPD_690 OUT x3_lockout GND_DRV GND_LOGIC nfet L=0.7U W=10U
Mx3_XMPD_691 OUT x3_lockout GND_DRV GND_LOGIC nfet L=0.7U W=10U
Mx3_XMPD_692 OUT x3_lockout GND_DRV GND_LOGIC nfet L=0.7U W=10U
Mx3_XMPD_693 OUT x3_lockout GND_DRV GND_LOGIC nfet L=0.7U W=10U
Mx3_XMPD_694 OUT x3_lockout GND_DRV GND_LOGIC nfet L=0.7U W=10U
Mx3_XMPD_695 OUT x3_lockout GND_DRV GND_LOGIC nfet L=0.7U W=10U
Mx3_XMPD_696 OUT x3_lockout GND_DRV GND_LOGIC nfet L=0.7U W=10U
Mx3_XMPD_697 OUT x3_lockout GND_DRV GND_LOGIC nfet L=0.7U W=10U
Mx3_XMPD_698 OUT x3_lockout GND_DRV GND_LOGIC nfet L=0.7U W=10U
Mx3_XMPD_699 OUT x3_lockout GND_DRV GND_LOGIC nfet L=0.7U W=10U
Mx3_XMPD_7 OUT x3_lockout GND_DRV GND_LOGIC nfet L=0.7U W=10U
Mx3_XMPD_70 OUT x3_lockout GND_DRV GND_LOGIC nfet L=0.7U W=10U
Mx3_XMPD_700 OUT x3_lockout GND_DRV GND_LOGIC nfet L=0.7U W=10U
Mx3_XMPD_701 OUT x3_lockout GND_DRV GND_LOGIC nfet L=0.7U W=10U
Mx3_XMPD_702 OUT x3_lockout GND_DRV GND_LOGIC nfet L=0.7U W=10U
Mx3_XMPD_703 OUT x3_lockout GND_DRV GND_LOGIC nfet L=0.7U W=10U
Mx3_XMPD_704 OUT x3_lockout GND_DRV GND_LOGIC nfet L=0.7U W=10U
Mx3_XMPD_705 OUT x3_lockout GND_DRV GND_LOGIC nfet L=0.7U W=10U
Mx3_XMPD_706 OUT x3_lockout GND_DRV GND_LOGIC nfet L=0.7U W=10U
Mx3_XMPD_707 OUT x3_lockout GND_DRV GND_LOGIC nfet L=0.7U W=10U
Mx3_XMPD_708 OUT x3_lockout GND_DRV GND_LOGIC nfet L=0.7U W=10U
Mx3_XMPD_709 OUT x3_lockout GND_DRV GND_LOGIC nfet L=0.7U W=10U
Mx3_XMPD_71 OUT x3_lockout GND_DRV GND_LOGIC nfet L=0.7U W=10U
Mx3_XMPD_710 OUT x3_lockout GND_DRV GND_LOGIC nfet L=0.7U W=10U
Mx3_XMPD_711 OUT x3_lockout GND_DRV GND_LOGIC nfet L=0.7U W=10U
Mx3_XMPD_712 OUT x3_lockout GND_DRV GND_LOGIC nfet L=0.7U W=10U
Mx3_XMPD_713 OUT x3_lockout GND_DRV GND_LOGIC nfet L=0.7U W=10U
Mx3_XMPD_714 OUT x3_lockout GND_DRV GND_LOGIC nfet L=0.7U W=10U
Mx3_XMPD_715 OUT x3_lockout GND_DRV GND_LOGIC nfet L=0.7U W=10U
Mx3_XMPD_716 OUT x3_lockout GND_DRV GND_LOGIC nfet L=0.7U W=10U
Mx3_XMPD_717 OUT x3_lockout GND_DRV GND_LOGIC nfet L=0.7U W=10U
Mx3_XMPD_718 OUT x3_lockout GND_DRV GND_LOGIC nfet L=0.7U W=10U
Mx3_XMPD_719 OUT x3_lockout GND_DRV GND_LOGIC nfet L=0.7U W=10U
Mx3_XMPD_72 OUT x3_lockout GND_DRV GND_LOGIC nfet L=0.7U W=10U
Mx3_XMPD_720 OUT x3_lockout GND_DRV GND_LOGIC nfet L=0.7U W=10U
Mx3_XMPD_721 OUT x3_lockout GND_DRV GND_LOGIC nfet L=0.7U W=10U
Mx3_XMPD_722 OUT x3_lockout GND_DRV GND_LOGIC nfet L=0.7U W=10U
Mx3_XMPD_723 OUT x3_lockout GND_DRV GND_LOGIC nfet L=0.7U W=10U
Mx3_XMPD_724 OUT x3_lockout GND_DRV GND_LOGIC nfet L=0.7U W=10U
Mx3_XMPD_725 OUT x3_lockout GND_DRV GND_LOGIC nfet L=0.7U W=10U
Mx3_XMPD_726 OUT x3_lockout GND_DRV GND_LOGIC nfet L=0.7U W=10U
Mx3_XMPD_727 OUT x3_lockout GND_DRV GND_LOGIC nfet L=0.7U W=10U
Mx3_XMPD_728 OUT x3_lockout GND_DRV GND_LOGIC nfet L=0.7U W=10U
Mx3_XMPD_729 OUT x3_lockout GND_DRV GND_LOGIC nfet L=0.7U W=10U
Mx3_XMPD_73 OUT x3_lockout GND_DRV GND_LOGIC nfet L=0.7U W=10U
Mx3_XMPD_730 OUT x3_lockout GND_DRV GND_LOGIC nfet L=0.7U W=10U
Mx3_XMPD_731 OUT x3_lockout GND_DRV GND_LOGIC nfet L=0.7U W=10U
Mx3_XMPD_732 OUT x3_lockout GND_DRV GND_LOGIC nfet L=0.7U W=10U
Mx3_XMPD_733 OUT x3_lockout GND_DRV GND_LOGIC nfet L=0.7U W=10U
Mx3_XMPD_734 OUT x3_lockout GND_DRV GND_LOGIC nfet L=0.7U W=10U
Mx3_XMPD_735 OUT x3_lockout GND_DRV GND_LOGIC nfet L=0.7U W=10U
Mx3_XMPD_736 OUT x3_lockout GND_DRV GND_LOGIC nfet L=0.7U W=10U
Mx3_XMPD_737 OUT x3_lockout GND_DRV GND_LOGIC nfet L=0.7U W=10U
Mx3_XMPD_738 OUT x3_lockout GND_DRV GND_LOGIC nfet L=0.7U W=10U
Mx3_XMPD_739 OUT x3_lockout GND_DRV GND_LOGIC nfet L=0.7U W=10U
Mx3_XMPD_74 OUT x3_lockout GND_DRV GND_LOGIC nfet L=0.7U W=10U
Mx3_XMPD_740 OUT x3_lockout GND_DRV GND_LOGIC nfet L=0.7U W=10U
Mx3_XMPD_741 OUT x3_lockout GND_DRV GND_LOGIC nfet L=0.7U W=10U
Mx3_XMPD_742 OUT x3_lockout GND_DRV GND_LOGIC nfet L=0.7U W=10U
Mx3_XMPD_743 OUT x3_lockout GND_DRV GND_LOGIC nfet L=0.7U W=10U
Mx3_XMPD_744 OUT x3_lockout GND_DRV GND_LOGIC nfet L=0.7U W=10U
Mx3_XMPD_745 OUT x3_lockout GND_DRV GND_LOGIC nfet L=0.7U W=10U
Mx3_XMPD_746 OUT x3_lockout GND_DRV GND_LOGIC nfet L=0.7U W=10U
Mx3_XMPD_747 OUT x3_lockout GND_DRV GND_LOGIC nfet L=0.7U W=10U
Mx3_XMPD_748 OUT x3_lockout GND_DRV GND_LOGIC nfet L=0.7U W=10U
Mx3_XMPD_749 OUT x3_lockout GND_DRV GND_LOGIC nfet L=0.7U W=10U
Mx3_XMPD_75 OUT x3_lockout GND_DRV GND_LOGIC nfet L=0.7U W=10U
Mx3_XMPD_750 OUT x3_lockout GND_DRV GND_LOGIC nfet L=0.7U W=10U
Mx3_XMPD_751 OUT x3_lockout GND_DRV GND_LOGIC nfet L=0.7U W=10U
Mx3_XMPD_752 OUT x3_lockout GND_DRV GND_LOGIC nfet L=0.7U W=10U
Mx3_XMPD_753 OUT x3_lockout GND_DRV GND_LOGIC nfet L=0.7U W=10U
Mx3_XMPD_754 OUT x3_lockout GND_DRV GND_LOGIC nfet L=0.7U W=10U
Mx3_XMPD_755 OUT x3_lockout GND_DRV GND_LOGIC nfet L=0.7U W=10U
Mx3_XMPD_756 OUT x3_lockout GND_DRV GND_LOGIC nfet L=0.7U W=10U
Mx3_XMPD_757 OUT x3_lockout GND_DRV GND_LOGIC nfet L=0.7U W=10U
Mx3_XMPD_758 OUT x3_lockout GND_DRV GND_LOGIC nfet L=0.7U W=10U
Mx3_XMPD_759 OUT x3_lockout GND_DRV GND_LOGIC nfet L=0.7U W=10U
Mx3_XMPD_76 OUT x3_lockout GND_DRV GND_LOGIC nfet L=0.7U W=10U
Mx3_XMPD_760 OUT x3_lockout GND_DRV GND_LOGIC nfet L=0.7U W=10U
Mx3_XMPD_761 OUT x3_lockout GND_DRV GND_LOGIC nfet L=0.7U W=10U
Mx3_XMPD_762 OUT x3_lockout GND_DRV GND_LOGIC nfet L=0.7U W=10U
Mx3_XMPD_763 OUT x3_lockout GND_DRV GND_LOGIC nfet L=0.7U W=10U
Mx3_XMPD_764 OUT x3_lockout GND_DRV GND_LOGIC nfet L=0.7U W=10U
Mx3_XMPD_765 OUT x3_lockout GND_DRV GND_LOGIC nfet L=0.7U W=10U
Mx3_XMPD_766 OUT x3_lockout GND_DRV GND_LOGIC nfet L=0.7U W=10U
Mx3_XMPD_767 OUT x3_lockout GND_DRV GND_LOGIC nfet L=0.7U W=10U
Mx3_XMPD_768 OUT x3_lockout GND_DRV GND_LOGIC nfet L=0.7U W=10U
Mx3_XMPD_769 OUT x3_lockout GND_DRV GND_LOGIC nfet L=0.7U W=10U
Mx3_XMPD_77 OUT x3_lockout GND_DRV GND_LOGIC nfet L=0.7U W=10U
Mx3_XMPD_770 OUT x3_lockout GND_DRV GND_LOGIC nfet L=0.7U W=10U
Mx3_XMPD_771 OUT x3_lockout GND_DRV GND_LOGIC nfet L=0.7U W=10U
Mx3_XMPD_772 OUT x3_lockout GND_DRV GND_LOGIC nfet L=0.7U W=10U
Mx3_XMPD_773 OUT x3_lockout GND_DRV GND_LOGIC nfet L=0.7U W=10U
Mx3_XMPD_774 OUT x3_lockout GND_DRV GND_LOGIC nfet L=0.7U W=10U
Mx3_XMPD_775 OUT x3_lockout GND_DRV GND_LOGIC nfet L=0.7U W=10U
Mx3_XMPD_776 OUT x3_lockout GND_DRV GND_LOGIC nfet L=0.7U W=10U
Mx3_XMPD_777 OUT x3_lockout GND_DRV GND_LOGIC nfet L=0.7U W=10U
Mx3_XMPD_778 OUT x3_lockout GND_DRV GND_LOGIC nfet L=0.7U W=10U
Mx3_XMPD_779 OUT x3_lockout GND_DRV GND_LOGIC nfet L=0.7U W=10U
Mx3_XMPD_78 OUT x3_lockout GND_DRV GND_LOGIC nfet L=0.7U W=10U
Mx3_XMPD_780 OUT x3_lockout GND_DRV GND_LOGIC nfet L=0.7U W=10U
Mx3_XMPD_781 OUT x3_lockout GND_DRV GND_LOGIC nfet L=0.7U W=10U
Mx3_XMPD_782 OUT x3_lockout GND_DRV GND_LOGIC nfet L=0.7U W=10U
Mx3_XMPD_783 OUT x3_lockout GND_DRV GND_LOGIC nfet L=0.7U W=10U
Mx3_XMPD_784 OUT x3_lockout GND_DRV GND_LOGIC nfet L=0.7U W=10U
Mx3_XMPD_785 OUT x3_lockout GND_DRV GND_LOGIC nfet L=0.7U W=10U
Mx3_XMPD_786 OUT x3_lockout GND_DRV GND_LOGIC nfet L=0.7U W=10U
Mx3_XMPD_787 OUT x3_lockout GND_DRV GND_LOGIC nfet L=0.7U W=10U
Mx3_XMPD_788 OUT x3_lockout GND_DRV GND_LOGIC nfet L=0.7U W=10U
Mx3_XMPD_789 OUT x3_lockout GND_DRV GND_LOGIC nfet L=0.7U W=10U
Mx3_XMPD_79 OUT x3_lockout GND_DRV GND_LOGIC nfet L=0.7U W=10U
Mx3_XMPD_790 OUT x3_lockout GND_DRV GND_LOGIC nfet L=0.7U W=10U
Mx3_XMPD_791 OUT x3_lockout GND_DRV GND_LOGIC nfet L=0.7U W=10U
Mx3_XMPD_792 OUT x3_lockout GND_DRV GND_LOGIC nfet L=0.7U W=10U
Mx3_XMPD_793 OUT x3_lockout GND_DRV GND_LOGIC nfet L=0.7U W=10U
Mx3_XMPD_794 OUT x3_lockout GND_DRV GND_LOGIC nfet L=0.7U W=10U
Mx3_XMPD_795 OUT x3_lockout GND_DRV GND_LOGIC nfet L=0.7U W=10U
Mx3_XMPD_796 OUT x3_lockout GND_DRV GND_LOGIC nfet L=0.7U W=10U
Mx3_XMPD_797 OUT x3_lockout GND_DRV GND_LOGIC nfet L=0.7U W=10U
Mx3_XMPD_798 OUT x3_lockout GND_DRV GND_LOGIC nfet L=0.7U W=10U
Mx3_XMPD_799 OUT x3_lockout GND_DRV GND_LOGIC nfet L=0.7U W=10U
Mx3_XMPD_8 OUT x3_lockout GND_DRV GND_LOGIC nfet L=0.7U W=10U
Mx3_XMPD_80 OUT x3_lockout GND_DRV GND_LOGIC nfet L=0.7U W=10U
Mx3_XMPD_81 OUT x3_lockout GND_DRV GND_LOGIC nfet L=0.7U W=10U
Mx3_XMPD_82 OUT x3_lockout GND_DRV GND_LOGIC nfet L=0.7U W=10U
Mx3_XMPD_83 OUT x3_lockout GND_DRV GND_LOGIC nfet L=0.7U W=10U
Mx3_XMPD_84 OUT x3_lockout GND_DRV GND_LOGIC nfet L=0.7U W=10U
Mx3_XMPD_85 OUT x3_lockout GND_DRV GND_LOGIC nfet L=0.7U W=10U
Mx3_XMPD_86 OUT x3_lockout GND_DRV GND_LOGIC nfet L=0.7U W=10U
Mx3_XMPD_87 OUT x3_lockout GND_DRV GND_LOGIC nfet L=0.7U W=10U
Mx3_XMPD_88 OUT x3_lockout GND_DRV GND_LOGIC nfet L=0.7U W=10U
Mx3_XMPD_89 OUT x3_lockout GND_DRV GND_LOGIC nfet L=0.7U W=10U
Mx3_XMPD_9 OUT x3_lockout GND_DRV GND_LOGIC nfet L=0.7U W=10U
Mx3_XMPD_90 OUT x3_lockout GND_DRV GND_LOGIC nfet L=0.7U W=10U
Mx3_XMPD_91 OUT x3_lockout GND_DRV GND_LOGIC nfet L=0.7U W=10U
Mx3_XMPD_92 OUT x3_lockout GND_DRV GND_LOGIC nfet L=0.7U W=10U
Mx3_XMPD_93 OUT x3_lockout GND_DRV GND_LOGIC nfet L=0.7U W=10U
Mx3_XMPD_94 OUT x3_lockout GND_DRV GND_LOGIC nfet L=0.7U W=10U
Mx3_XMPD_95 OUT x3_lockout GND_DRV GND_LOGIC nfet L=0.7U W=10U
Mx3_XMPD_96 OUT x3_lockout GND_DRV GND_LOGIC nfet L=0.7U W=10U
Mx3_XMPD_97 OUT x3_lockout GND_DRV GND_LOGIC nfet L=0.7U W=10U
Mx3_XMPD_98 OUT x3_lockout GND_DRV GND_LOGIC nfet L=0.7U W=10U
Mx3_XMPD_99 OUT x3_lockout GND_DRV GND_LOGIC nfet L=0.7U W=10U
Mx3_XMPINV1_0 x3_lockout x3_ncompn VDD_DRV VDD_DRV pfet L=0.55U W=10U
Mx3_XMPINV2_0 x3_uvlo_ok x3_lockout VDD_DRV VDD_DRV pfet L=0.55U W=20U
Mx3_XMREF_0 x3_nref x3_nref GND_DRV GND_LOGIC nfet L=0.7U W=10U
Mx3_XMTAIL_0 x3_ntail x3_nref GND_DRV GND_LOGIC nfet L=0.7U W=20U
Rx3_R1_0 VDD_DRV x3_R1_n1 GND_LOGIC ppolyf_u R=55000
Rx3_R1_1 x3_R1_n1 x3_R1_n2 GND_LOGIC ppolyf_u R=55000
Rx3_R1_10 x3_R1_n10 x3_R1_n11 GND_LOGIC ppolyf_u R=55000
Rx3_R1_11 x3_R1_n11 x3_R1_n12 GND_LOGIC ppolyf_u R=55000
Rx3_R1_12 x3_R1_n12 x3_R1_n13 GND_LOGIC ppolyf_u R=55000
Rx3_R1_13 x3_R1_n13 x3_R1_n14 GND_LOGIC ppolyf_u R=55000
Rx3_R1_14 x3_R1_n14 x3_R1_n15 GND_LOGIC ppolyf_u R=55000
Rx3_R1_15 x3_R1_n15 x3_ndiv GND_LOGIC ppolyf_u R=55000
Rx3_R1_2 x3_R1_n2 x3_R1_n3 GND_LOGIC ppolyf_u R=55000
Rx3_R1_3 x3_R1_n3 x3_R1_n4 GND_LOGIC ppolyf_u R=55000
Rx3_R1_4 x3_R1_n4 x3_R1_n5 GND_LOGIC ppolyf_u R=55000
Rx3_R1_5 x3_R1_n5 x3_R1_n6 GND_LOGIC ppolyf_u R=55000
Rx3_R1_6 x3_R1_n6 x3_R1_n7 GND_LOGIC ppolyf_u R=55000
Rx3_R1_7 x3_R1_n7 x3_R1_n8 GND_LOGIC ppolyf_u R=55000
Rx3_R1_8 x3_R1_n8 x3_R1_n9 GND_LOGIC ppolyf_u R=55000
Rx3_R1_9 x3_R1_n9 x3_R1_n10 GND_LOGIC ppolyf_u R=55000
Rx3_R2_0 x3_ndiv x3_R2_n1 GND_LOGIC ppolyf_u R=66666.6667
Rx3_R2_1 x3_R2_n1 x3_R2_n2 GND_LOGIC ppolyf_u R=66666.6667
Rx3_R2_2 x3_R2_n2 GND_DRV GND_LOGIC ppolyf_u R=66666.6667
Rx3_Rfb_0 x3_uvlo_ok x3_Rfb_n1 GND_LOGIC ppolyf_u R=66666.6667
Rx3_Rfb_1 x3_Rfb_n1 x3_Rfb_n2 GND_LOGIC ppolyf_u R=66666.6667
Rx3_Rfb_10 x3_Rfb_n10 x3_Rfb_n11 GND_LOGIC ppolyf_u R=66666.6667
Rx3_Rfb_100 x3_Rfb_n100 x3_Rfb_n101 GND_LOGIC ppolyf_u R=66666.6667
Rx3_Rfb_101 x3_Rfb_n101 x3_Rfb_n102 GND_LOGIC ppolyf_u R=66666.6667
Rx3_Rfb_102 x3_Rfb_n102 x3_Rfb_n103 GND_LOGIC ppolyf_u R=66666.6667
Rx3_Rfb_103 x3_Rfb_n103 x3_Rfb_n104 GND_LOGIC ppolyf_u R=66666.6667
Rx3_Rfb_104 x3_Rfb_n104 x3_Rfb_n105 GND_LOGIC ppolyf_u R=66666.6667
Rx3_Rfb_105 x3_Rfb_n105 x3_Rfb_n106 GND_LOGIC ppolyf_u R=66666.6667
Rx3_Rfb_106 x3_Rfb_n106 x3_Rfb_n107 GND_LOGIC ppolyf_u R=66666.6667
Rx3_Rfb_107 x3_Rfb_n107 x3_Rfb_n108 GND_LOGIC ppolyf_u R=66666.6667
Rx3_Rfb_108 x3_Rfb_n108 x3_Rfb_n109 GND_LOGIC ppolyf_u R=66666.6667
Rx3_Rfb_109 x3_Rfb_n109 x3_Rfb_n110 GND_LOGIC ppolyf_u R=66666.6667
Rx3_Rfb_11 x3_Rfb_n11 x3_Rfb_n12 GND_LOGIC ppolyf_u R=66666.6667
Rx3_Rfb_110 x3_Rfb_n110 x3_Rfb_n111 GND_LOGIC ppolyf_u R=66666.6667
Rx3_Rfb_111 x3_Rfb_n111 x3_Rfb_n112 GND_LOGIC ppolyf_u R=66666.6667
Rx3_Rfb_112 x3_Rfb_n112 x3_Rfb_n113 GND_LOGIC ppolyf_u R=66666.6667
Rx3_Rfb_113 x3_Rfb_n113 x3_Rfb_n114 GND_LOGIC ppolyf_u R=66666.6667
Rx3_Rfb_114 x3_Rfb_n114 x3_Rfb_n115 GND_LOGIC ppolyf_u R=66666.6667
Rx3_Rfb_115 x3_Rfb_n115 x3_Rfb_n116 GND_LOGIC ppolyf_u R=66666.6667
Rx3_Rfb_116 x3_Rfb_n116 x3_Rfb_n117 GND_LOGIC ppolyf_u R=66666.6667
Rx3_Rfb_117 x3_Rfb_n117 x3_Rfb_n118 GND_LOGIC ppolyf_u R=66666.6667
Rx3_Rfb_118 x3_Rfb_n118 x3_Rfb_n119 GND_LOGIC ppolyf_u R=66666.6667
Rx3_Rfb_119 x3_Rfb_n119 x3_Rfb_n120 GND_LOGIC ppolyf_u R=66666.6667
Rx3_Rfb_12 x3_Rfb_n12 x3_Rfb_n13 GND_LOGIC ppolyf_u R=66666.6667
Rx3_Rfb_120 x3_Rfb_n120 x3_Rfb_n121 GND_LOGIC ppolyf_u R=66666.6667
Rx3_Rfb_121 x3_Rfb_n121 x3_Rfb_n122 GND_LOGIC ppolyf_u R=66666.6667
Rx3_Rfb_122 x3_Rfb_n122 x3_Rfb_n123 GND_LOGIC ppolyf_u R=66666.6667
Rx3_Rfb_123 x3_Rfb_n123 x3_Rfb_n124 GND_LOGIC ppolyf_u R=66666.6667
Rx3_Rfb_124 x3_Rfb_n124 x3_Rfb_n125 GND_LOGIC ppolyf_u R=66666.6667
Rx3_Rfb_125 x3_Rfb_n125 x3_Rfb_n126 GND_LOGIC ppolyf_u R=66666.6667
Rx3_Rfb_126 x3_Rfb_n126 x3_Rfb_n127 GND_LOGIC ppolyf_u R=66666.6667
Rx3_Rfb_127 x3_Rfb_n127 x3_Rfb_n128 GND_LOGIC ppolyf_u R=66666.6667
Rx3_Rfb_128 x3_Rfb_n128 x3_Rfb_n129 GND_LOGIC ppolyf_u R=66666.6667
Rx3_Rfb_129 x3_Rfb_n129 x3_Rfb_n130 GND_LOGIC ppolyf_u R=66666.6667
Rx3_Rfb_13 x3_Rfb_n13 x3_Rfb_n14 GND_LOGIC ppolyf_u R=66666.6667
Rx3_Rfb_130 x3_Rfb_n130 x3_Rfb_n131 GND_LOGIC ppolyf_u R=66666.6667
Rx3_Rfb_131 x3_Rfb_n131 x3_Rfb_n132 GND_LOGIC ppolyf_u R=66666.6667
Rx3_Rfb_132 x3_Rfb_n132 x3_Rfb_n133 GND_LOGIC ppolyf_u R=66666.6667
Rx3_Rfb_133 x3_Rfb_n133 x3_Rfb_n134 GND_LOGIC ppolyf_u R=66666.6667
Rx3_Rfb_134 x3_Rfb_n134 x3_Rfb_n135 GND_LOGIC ppolyf_u R=66666.6667
Rx3_Rfb_135 x3_Rfb_n135 x3_Rfb_n136 GND_LOGIC ppolyf_u R=66666.6667
Rx3_Rfb_136 x3_Rfb_n136 x3_Rfb_n137 GND_LOGIC ppolyf_u R=66666.6667
Rx3_Rfb_137 x3_Rfb_n137 x3_Rfb_n138 GND_LOGIC ppolyf_u R=66666.6667
Rx3_Rfb_138 x3_Rfb_n138 x3_Rfb_n139 GND_LOGIC ppolyf_u R=66666.6667
Rx3_Rfb_139 x3_Rfb_n139 x3_Rfb_n140 GND_LOGIC ppolyf_u R=66666.6667
Rx3_Rfb_14 x3_Rfb_n14 x3_Rfb_n15 GND_LOGIC ppolyf_u R=66666.6667
Rx3_Rfb_140 x3_Rfb_n140 x3_Rfb_n141 GND_LOGIC ppolyf_u R=66666.6667
Rx3_Rfb_141 x3_Rfb_n141 x3_Rfb_n142 GND_LOGIC ppolyf_u R=66666.6667
Rx3_Rfb_142 x3_Rfb_n142 x3_Rfb_n143 GND_LOGIC ppolyf_u R=66666.6667
Rx3_Rfb_143 x3_Rfb_n143 x3_Rfb_n144 GND_LOGIC ppolyf_u R=66666.6667
Rx3_Rfb_144 x3_Rfb_n144 x3_Rfb_n145 GND_LOGIC ppolyf_u R=66666.6667
Rx3_Rfb_145 x3_Rfb_n145 x3_Rfb_n146 GND_LOGIC ppolyf_u R=66666.6667
Rx3_Rfb_146 x3_Rfb_n146 x3_Rfb_n147 GND_LOGIC ppolyf_u R=66666.6667
Rx3_Rfb_147 x3_Rfb_n147 x3_Rfb_n148 GND_LOGIC ppolyf_u R=66666.6667
Rx3_Rfb_148 x3_Rfb_n148 x3_Rfb_n149 GND_LOGIC ppolyf_u R=66666.6667
Rx3_Rfb_149 x3_Rfb_n149 x3_Rfb_n150 GND_LOGIC ppolyf_u R=66666.6667
Rx3_Rfb_15 x3_Rfb_n15 x3_Rfb_n16 GND_LOGIC ppolyf_u R=66666.6667
Rx3_Rfb_150 x3_Rfb_n150 x3_Rfb_n151 GND_LOGIC ppolyf_u R=66666.6667
Rx3_Rfb_151 x3_Rfb_n151 x3_Rfb_n152 GND_LOGIC ppolyf_u R=66666.6667
Rx3_Rfb_152 x3_Rfb_n152 x3_Rfb_n153 GND_LOGIC ppolyf_u R=66666.6667
Rx3_Rfb_153 x3_Rfb_n153 x3_Rfb_n154 GND_LOGIC ppolyf_u R=66666.6667
Rx3_Rfb_154 x3_Rfb_n154 x3_Rfb_n155 GND_LOGIC ppolyf_u R=66666.6667
Rx3_Rfb_155 x3_Rfb_n155 x3_Rfb_n156 GND_LOGIC ppolyf_u R=66666.6667
Rx3_Rfb_156 x3_Rfb_n156 x3_Rfb_n157 GND_LOGIC ppolyf_u R=66666.6667
Rx3_Rfb_157 x3_Rfb_n157 x3_Rfb_n158 GND_LOGIC ppolyf_u R=66666.6667
Rx3_Rfb_158 x3_Rfb_n158 x3_Rfb_n159 GND_LOGIC ppolyf_u R=66666.6667
Rx3_Rfb_159 x3_Rfb_n159 x3_Rfb_n160 GND_LOGIC ppolyf_u R=66666.6667
Rx3_Rfb_16 x3_Rfb_n16 x3_Rfb_n17 GND_LOGIC ppolyf_u R=66666.6667
Rx3_Rfb_160 x3_Rfb_n160 x3_Rfb_n161 GND_LOGIC ppolyf_u R=66666.6667
Rx3_Rfb_161 x3_Rfb_n161 x3_Rfb_n162 GND_LOGIC ppolyf_u R=66666.6667
Rx3_Rfb_162 x3_Rfb_n162 x3_Rfb_n163 GND_LOGIC ppolyf_u R=66666.6667
Rx3_Rfb_163 x3_Rfb_n163 x3_Rfb_n164 GND_LOGIC ppolyf_u R=66666.6667
Rx3_Rfb_164 x3_Rfb_n164 x3_Rfb_n165 GND_LOGIC ppolyf_u R=66666.6667
Rx3_Rfb_165 x3_Rfb_n165 x3_Rfb_n166 GND_LOGIC ppolyf_u R=66666.6667
Rx3_Rfb_166 x3_Rfb_n166 x3_Rfb_n167 GND_LOGIC ppolyf_u R=66666.6667
Rx3_Rfb_167 x3_Rfb_n167 x3_Rfb_n168 GND_LOGIC ppolyf_u R=66666.6667
Rx3_Rfb_168 x3_Rfb_n168 x3_Rfb_n169 GND_LOGIC ppolyf_u R=66666.6667
Rx3_Rfb_169 x3_Rfb_n169 x3_Rfb_n170 GND_LOGIC ppolyf_u R=66666.6667
Rx3_Rfb_17 x3_Rfb_n17 x3_Rfb_n18 GND_LOGIC ppolyf_u R=66666.6667
Rx3_Rfb_170 x3_Rfb_n170 x3_Rfb_n171 GND_LOGIC ppolyf_u R=66666.6667
Rx3_Rfb_171 x3_Rfb_n171 x3_Rfb_n172 GND_LOGIC ppolyf_u R=66666.6667
Rx3_Rfb_172 x3_Rfb_n172 x3_Rfb_n173 GND_LOGIC ppolyf_u R=66666.6667
Rx3_Rfb_173 x3_Rfb_n173 x3_Rfb_n174 GND_LOGIC ppolyf_u R=66666.6667
Rx3_Rfb_174 x3_Rfb_n174 x3_Rfb_n175 GND_LOGIC ppolyf_u R=66666.6667
Rx3_Rfb_175 x3_Rfb_n175 x3_Rfb_n176 GND_LOGIC ppolyf_u R=66666.6667
Rx3_Rfb_176 x3_Rfb_n176 x3_Rfb_n177 GND_LOGIC ppolyf_u R=66666.6667
Rx3_Rfb_177 x3_Rfb_n177 x3_Rfb_n178 GND_LOGIC ppolyf_u R=66666.6667
Rx3_Rfb_178 x3_Rfb_n178 x3_Rfb_n179 GND_LOGIC ppolyf_u R=66666.6667
Rx3_Rfb_179 x3_Rfb_n179 x3_Rfb_n180 GND_LOGIC ppolyf_u R=66666.6667
Rx3_Rfb_18 x3_Rfb_n18 x3_Rfb_n19 GND_LOGIC ppolyf_u R=66666.6667
Rx3_Rfb_180 x3_Rfb_n180 x3_Rfb_n181 GND_LOGIC ppolyf_u R=66666.6667
Rx3_Rfb_181 x3_Rfb_n181 x3_Rfb_n182 GND_LOGIC ppolyf_u R=66666.6667
Rx3_Rfb_182 x3_Rfb_n182 x3_Rfb_n183 GND_LOGIC ppolyf_u R=66666.6667
Rx3_Rfb_183 x3_Rfb_n183 x3_Rfb_n184 GND_LOGIC ppolyf_u R=66666.6667
Rx3_Rfb_184 x3_Rfb_n184 x3_Rfb_n185 GND_LOGIC ppolyf_u R=66666.6667
Rx3_Rfb_185 x3_Rfb_n185 x3_Rfb_n186 GND_LOGIC ppolyf_u R=66666.6667
Rx3_Rfb_186 x3_Rfb_n186 x3_Rfb_n187 GND_LOGIC ppolyf_u R=66666.6667
Rx3_Rfb_187 x3_Rfb_n187 x3_Rfb_n188 GND_LOGIC ppolyf_u R=66666.6667
Rx3_Rfb_188 x3_Rfb_n188 x3_Rfb_n189 GND_LOGIC ppolyf_u R=66666.6667
Rx3_Rfb_189 x3_Rfb_n189 x3_Rfb_n190 GND_LOGIC ppolyf_u R=66666.6667
Rx3_Rfb_19 x3_Rfb_n19 x3_Rfb_n20 GND_LOGIC ppolyf_u R=66666.6667
Rx3_Rfb_190 x3_Rfb_n190 x3_Rfb_n191 GND_LOGIC ppolyf_u R=66666.6667
Rx3_Rfb_191 x3_Rfb_n191 x3_Rfb_n192 GND_LOGIC ppolyf_u R=66666.6667
Rx3_Rfb_192 x3_Rfb_n192 x3_Rfb_n193 GND_LOGIC ppolyf_u R=66666.6667
Rx3_Rfb_193 x3_Rfb_n193 x3_Rfb_n194 GND_LOGIC ppolyf_u R=66666.6667
Rx3_Rfb_194 x3_Rfb_n194 x3_Rfb_n195 GND_LOGIC ppolyf_u R=66666.6667
Rx3_Rfb_195 x3_Rfb_n195 x3_Rfb_n196 GND_LOGIC ppolyf_u R=66666.6667
Rx3_Rfb_196 x3_Rfb_n196 x3_Rfb_n197 GND_LOGIC ppolyf_u R=66666.6667
Rx3_Rfb_197 x3_Rfb_n197 x3_Rfb_n198 GND_LOGIC ppolyf_u R=66666.6667
Rx3_Rfb_198 x3_Rfb_n198 x3_Rfb_n199 GND_LOGIC ppolyf_u R=66666.6667
Rx3_Rfb_199 x3_Rfb_n199 x3_Rfb_n200 GND_LOGIC ppolyf_u R=66666.6667
Rx3_Rfb_2 x3_Rfb_n2 x3_Rfb_n3 GND_LOGIC ppolyf_u R=66666.6667
Rx3_Rfb_20 x3_Rfb_n20 x3_Rfb_n21 GND_LOGIC ppolyf_u R=66666.6667
Rx3_Rfb_200 x3_Rfb_n200 x3_Rfb_n201 GND_LOGIC ppolyf_u R=66666.6667
Rx3_Rfb_201 x3_Rfb_n201 x3_Rfb_n202 GND_LOGIC ppolyf_u R=66666.6667
Rx3_Rfb_202 x3_Rfb_n202 x3_Rfb_n203 GND_LOGIC ppolyf_u R=66666.6667
Rx3_Rfb_203 x3_Rfb_n203 x3_Rfb_n204 GND_LOGIC ppolyf_u R=66666.6667
Rx3_Rfb_204 x3_Rfb_n204 x3_Rfb_n205 GND_LOGIC ppolyf_u R=66666.6667
Rx3_Rfb_205 x3_Rfb_n205 x3_Rfb_n206 GND_LOGIC ppolyf_u R=66666.6667
Rx3_Rfb_206 x3_Rfb_n206 x3_Rfb_n207 GND_LOGIC ppolyf_u R=66666.6667
Rx3_Rfb_207 x3_Rfb_n207 x3_Rfb_n208 GND_LOGIC ppolyf_u R=66666.6667
Rx3_Rfb_208 x3_Rfb_n208 x3_Rfb_n209 GND_LOGIC ppolyf_u R=66666.6667
Rx3_Rfb_209 x3_Rfb_n209 x3_Rfb_n210 GND_LOGIC ppolyf_u R=66666.6667
Rx3_Rfb_21 x3_Rfb_n21 x3_Rfb_n22 GND_LOGIC ppolyf_u R=66666.6667
Rx3_Rfb_210 x3_Rfb_n210 x3_Rfb_n211 GND_LOGIC ppolyf_u R=66666.6667
Rx3_Rfb_211 x3_Rfb_n211 x3_Rfb_n212 GND_LOGIC ppolyf_u R=66666.6667
Rx3_Rfb_212 x3_Rfb_n212 x3_Rfb_n213 GND_LOGIC ppolyf_u R=66666.6667
Rx3_Rfb_213 x3_Rfb_n213 x3_Rfb_n214 GND_LOGIC ppolyf_u R=66666.6667
Rx3_Rfb_214 x3_Rfb_n214 x3_Rfb_n215 GND_LOGIC ppolyf_u R=66666.6667
Rx3_Rfb_215 x3_Rfb_n215 x3_Rfb_n216 GND_LOGIC ppolyf_u R=66666.6667
Rx3_Rfb_216 x3_Rfb_n216 x3_Rfb_n217 GND_LOGIC ppolyf_u R=66666.6667
Rx3_Rfb_217 x3_Rfb_n217 x3_Rfb_n218 GND_LOGIC ppolyf_u R=66666.6667
Rx3_Rfb_218 x3_Rfb_n218 x3_Rfb_n219 GND_LOGIC ppolyf_u R=66666.6667
Rx3_Rfb_219 x3_Rfb_n219 x3_Rfb_n220 GND_LOGIC ppolyf_u R=66666.6667
Rx3_Rfb_22 x3_Rfb_n22 x3_Rfb_n23 GND_LOGIC ppolyf_u R=66666.6667
Rx3_Rfb_220 x3_Rfb_n220 x3_Rfb_n221 GND_LOGIC ppolyf_u R=66666.6667
Rx3_Rfb_221 x3_Rfb_n221 x3_Rfb_n222 GND_LOGIC ppolyf_u R=66666.6667
Rx3_Rfb_222 x3_Rfb_n222 x3_Rfb_n223 GND_LOGIC ppolyf_u R=66666.6667
Rx3_Rfb_223 x3_Rfb_n223 x3_Rfb_n224 GND_LOGIC ppolyf_u R=66666.6667
Rx3_Rfb_224 x3_Rfb_n224 x3_Rfb_n225 GND_LOGIC ppolyf_u R=66666.6667
Rx3_Rfb_225 x3_Rfb_n225 x3_Rfb_n226 GND_LOGIC ppolyf_u R=66666.6667
Rx3_Rfb_226 x3_Rfb_n226 x3_Rfb_n227 GND_LOGIC ppolyf_u R=66666.6667
Rx3_Rfb_227 x3_Rfb_n227 x3_Rfb_n228 GND_LOGIC ppolyf_u R=66666.6667
Rx3_Rfb_228 x3_Rfb_n228 x3_Rfb_n229 GND_LOGIC ppolyf_u R=66666.6667
Rx3_Rfb_229 x3_Rfb_n229 x3_Rfb_n230 GND_LOGIC ppolyf_u R=66666.6667
Rx3_Rfb_23 x3_Rfb_n23 x3_Rfb_n24 GND_LOGIC ppolyf_u R=66666.6667
Rx3_Rfb_230 x3_Rfb_n230 x3_Rfb_n231 GND_LOGIC ppolyf_u R=66666.6667
Rx3_Rfb_231 x3_Rfb_n231 x3_Rfb_n232 GND_LOGIC ppolyf_u R=66666.6667
Rx3_Rfb_232 x3_Rfb_n232 x3_Rfb_n233 GND_LOGIC ppolyf_u R=66666.6667
Rx3_Rfb_233 x3_Rfb_n233 x3_Rfb_n234 GND_LOGIC ppolyf_u R=66666.6667
Rx3_Rfb_234 x3_Rfb_n234 x3_Rfb_n235 GND_LOGIC ppolyf_u R=66666.6667
Rx3_Rfb_235 x3_Rfb_n235 x3_Rfb_n236 GND_LOGIC ppolyf_u R=66666.6667
Rx3_Rfb_236 x3_Rfb_n236 x3_Rfb_n237 GND_LOGIC ppolyf_u R=66666.6667
Rx3_Rfb_237 x3_Rfb_n237 x3_Rfb_n238 GND_LOGIC ppolyf_u R=66666.6667
Rx3_Rfb_238 x3_Rfb_n238 x3_Rfb_n239 GND_LOGIC ppolyf_u R=66666.6667
Rx3_Rfb_239 x3_Rfb_n239 x3_ndiv GND_LOGIC ppolyf_u R=66666.6667
Rx3_Rfb_24 x3_Rfb_n24 x3_Rfb_n25 GND_LOGIC ppolyf_u R=66666.6667
Rx3_Rfb_25 x3_Rfb_n25 x3_Rfb_n26 GND_LOGIC ppolyf_u R=66666.6667
Rx3_Rfb_26 x3_Rfb_n26 x3_Rfb_n27 GND_LOGIC ppolyf_u R=66666.6667
Rx3_Rfb_27 x3_Rfb_n27 x3_Rfb_n28 GND_LOGIC ppolyf_u R=66666.6667
Rx3_Rfb_28 x3_Rfb_n28 x3_Rfb_n29 GND_LOGIC ppolyf_u R=66666.6667
Rx3_Rfb_29 x3_Rfb_n29 x3_Rfb_n30 GND_LOGIC ppolyf_u R=66666.6667
Rx3_Rfb_3 x3_Rfb_n3 x3_Rfb_n4 GND_LOGIC ppolyf_u R=66666.6667
Rx3_Rfb_30 x3_Rfb_n30 x3_Rfb_n31 GND_LOGIC ppolyf_u R=66666.6667
Rx3_Rfb_31 x3_Rfb_n31 x3_Rfb_n32 GND_LOGIC ppolyf_u R=66666.6667
Rx3_Rfb_32 x3_Rfb_n32 x3_Rfb_n33 GND_LOGIC ppolyf_u R=66666.6667
Rx3_Rfb_33 x3_Rfb_n33 x3_Rfb_n34 GND_LOGIC ppolyf_u R=66666.6667
Rx3_Rfb_34 x3_Rfb_n34 x3_Rfb_n35 GND_LOGIC ppolyf_u R=66666.6667
Rx3_Rfb_35 x3_Rfb_n35 x3_Rfb_n36 GND_LOGIC ppolyf_u R=66666.6667
Rx3_Rfb_36 x3_Rfb_n36 x3_Rfb_n37 GND_LOGIC ppolyf_u R=66666.6667
Rx3_Rfb_37 x3_Rfb_n37 x3_Rfb_n38 GND_LOGIC ppolyf_u R=66666.6667
Rx3_Rfb_38 x3_Rfb_n38 x3_Rfb_n39 GND_LOGIC ppolyf_u R=66666.6667
Rx3_Rfb_39 x3_Rfb_n39 x3_Rfb_n40 GND_LOGIC ppolyf_u R=66666.6667
Rx3_Rfb_4 x3_Rfb_n4 x3_Rfb_n5 GND_LOGIC ppolyf_u R=66666.6667
Rx3_Rfb_40 x3_Rfb_n40 x3_Rfb_n41 GND_LOGIC ppolyf_u R=66666.6667
Rx3_Rfb_41 x3_Rfb_n41 x3_Rfb_n42 GND_LOGIC ppolyf_u R=66666.6667
Rx3_Rfb_42 x3_Rfb_n42 x3_Rfb_n43 GND_LOGIC ppolyf_u R=66666.6667
Rx3_Rfb_43 x3_Rfb_n43 x3_Rfb_n44 GND_LOGIC ppolyf_u R=66666.6667
Rx3_Rfb_44 x3_Rfb_n44 x3_Rfb_n45 GND_LOGIC ppolyf_u R=66666.6667
Rx3_Rfb_45 x3_Rfb_n45 x3_Rfb_n46 GND_LOGIC ppolyf_u R=66666.6667
Rx3_Rfb_46 x3_Rfb_n46 x3_Rfb_n47 GND_LOGIC ppolyf_u R=66666.6667
Rx3_Rfb_47 x3_Rfb_n47 x3_Rfb_n48 GND_LOGIC ppolyf_u R=66666.6667
Rx3_Rfb_48 x3_Rfb_n48 x3_Rfb_n49 GND_LOGIC ppolyf_u R=66666.6667
Rx3_Rfb_49 x3_Rfb_n49 x3_Rfb_n50 GND_LOGIC ppolyf_u R=66666.6667
Rx3_Rfb_5 x3_Rfb_n5 x3_Rfb_n6 GND_LOGIC ppolyf_u R=66666.6667
Rx3_Rfb_50 x3_Rfb_n50 x3_Rfb_n51 GND_LOGIC ppolyf_u R=66666.6667
Rx3_Rfb_51 x3_Rfb_n51 x3_Rfb_n52 GND_LOGIC ppolyf_u R=66666.6667
Rx3_Rfb_52 x3_Rfb_n52 x3_Rfb_n53 GND_LOGIC ppolyf_u R=66666.6667
Rx3_Rfb_53 x3_Rfb_n53 x3_Rfb_n54 GND_LOGIC ppolyf_u R=66666.6667
Rx3_Rfb_54 x3_Rfb_n54 x3_Rfb_n55 GND_LOGIC ppolyf_u R=66666.6667
Rx3_Rfb_55 x3_Rfb_n55 x3_Rfb_n56 GND_LOGIC ppolyf_u R=66666.6667
Rx3_Rfb_56 x3_Rfb_n56 x3_Rfb_n57 GND_LOGIC ppolyf_u R=66666.6667
Rx3_Rfb_57 x3_Rfb_n57 x3_Rfb_n58 GND_LOGIC ppolyf_u R=66666.6667
Rx3_Rfb_58 x3_Rfb_n58 x3_Rfb_n59 GND_LOGIC ppolyf_u R=66666.6667
Rx3_Rfb_59 x3_Rfb_n59 x3_Rfb_n60 GND_LOGIC ppolyf_u R=66666.6667
Rx3_Rfb_6 x3_Rfb_n6 x3_Rfb_n7 GND_LOGIC ppolyf_u R=66666.6667
Rx3_Rfb_60 x3_Rfb_n60 x3_Rfb_n61 GND_LOGIC ppolyf_u R=66666.6667
Rx3_Rfb_61 x3_Rfb_n61 x3_Rfb_n62 GND_LOGIC ppolyf_u R=66666.6667
Rx3_Rfb_62 x3_Rfb_n62 x3_Rfb_n63 GND_LOGIC ppolyf_u R=66666.6667
Rx3_Rfb_63 x3_Rfb_n63 x3_Rfb_n64 GND_LOGIC ppolyf_u R=66666.6667
Rx3_Rfb_64 x3_Rfb_n64 x3_Rfb_n65 GND_LOGIC ppolyf_u R=66666.6667
Rx3_Rfb_65 x3_Rfb_n65 x3_Rfb_n66 GND_LOGIC ppolyf_u R=66666.6667
Rx3_Rfb_66 x3_Rfb_n66 x3_Rfb_n67 GND_LOGIC ppolyf_u R=66666.6667
Rx3_Rfb_67 x3_Rfb_n67 x3_Rfb_n68 GND_LOGIC ppolyf_u R=66666.6667
Rx3_Rfb_68 x3_Rfb_n68 x3_Rfb_n69 GND_LOGIC ppolyf_u R=66666.6667
Rx3_Rfb_69 x3_Rfb_n69 x3_Rfb_n70 GND_LOGIC ppolyf_u R=66666.6667
Rx3_Rfb_7 x3_Rfb_n7 x3_Rfb_n8 GND_LOGIC ppolyf_u R=66666.6667
Rx3_Rfb_70 x3_Rfb_n70 x3_Rfb_n71 GND_LOGIC ppolyf_u R=66666.6667
Rx3_Rfb_71 x3_Rfb_n71 x3_Rfb_n72 GND_LOGIC ppolyf_u R=66666.6667
Rx3_Rfb_72 x3_Rfb_n72 x3_Rfb_n73 GND_LOGIC ppolyf_u R=66666.6667
Rx3_Rfb_73 x3_Rfb_n73 x3_Rfb_n74 GND_LOGIC ppolyf_u R=66666.6667
Rx3_Rfb_74 x3_Rfb_n74 x3_Rfb_n75 GND_LOGIC ppolyf_u R=66666.6667
Rx3_Rfb_75 x3_Rfb_n75 x3_Rfb_n76 GND_LOGIC ppolyf_u R=66666.6667
Rx3_Rfb_76 x3_Rfb_n76 x3_Rfb_n77 GND_LOGIC ppolyf_u R=66666.6667
Rx3_Rfb_77 x3_Rfb_n77 x3_Rfb_n78 GND_LOGIC ppolyf_u R=66666.6667
Rx3_Rfb_78 x3_Rfb_n78 x3_Rfb_n79 GND_LOGIC ppolyf_u R=66666.6667
Rx3_Rfb_79 x3_Rfb_n79 x3_Rfb_n80 GND_LOGIC ppolyf_u R=66666.6667
Rx3_Rfb_8 x3_Rfb_n8 x3_Rfb_n9 GND_LOGIC ppolyf_u R=66666.6667
Rx3_Rfb_80 x3_Rfb_n80 x3_Rfb_n81 GND_LOGIC ppolyf_u R=66666.6667
Rx3_Rfb_81 x3_Rfb_n81 x3_Rfb_n82 GND_LOGIC ppolyf_u R=66666.6667
Rx3_Rfb_82 x3_Rfb_n82 x3_Rfb_n83 GND_LOGIC ppolyf_u R=66666.6667
Rx3_Rfb_83 x3_Rfb_n83 x3_Rfb_n84 GND_LOGIC ppolyf_u R=66666.6667
Rx3_Rfb_84 x3_Rfb_n84 x3_Rfb_n85 GND_LOGIC ppolyf_u R=66666.6667
Rx3_Rfb_85 x3_Rfb_n85 x3_Rfb_n86 GND_LOGIC ppolyf_u R=66666.6667
Rx3_Rfb_86 x3_Rfb_n86 x3_Rfb_n87 GND_LOGIC ppolyf_u R=66666.6667
Rx3_Rfb_87 x3_Rfb_n87 x3_Rfb_n88 GND_LOGIC ppolyf_u R=66666.6667
Rx3_Rfb_88 x3_Rfb_n88 x3_Rfb_n89 GND_LOGIC ppolyf_u R=66666.6667
Rx3_Rfb_89 x3_Rfb_n89 x3_Rfb_n90 GND_LOGIC ppolyf_u R=66666.6667
Rx3_Rfb_9 x3_Rfb_n9 x3_Rfb_n10 GND_LOGIC ppolyf_u R=66666.6667
Rx3_Rfb_90 x3_Rfb_n90 x3_Rfb_n91 GND_LOGIC ppolyf_u R=66666.6667
Rx3_Rfb_91 x3_Rfb_n91 x3_Rfb_n92 GND_LOGIC ppolyf_u R=66666.6667
Rx3_Rfb_92 x3_Rfb_n92 x3_Rfb_n93 GND_LOGIC ppolyf_u R=66666.6667
Rx3_Rfb_93 x3_Rfb_n93 x3_Rfb_n94 GND_LOGIC ppolyf_u R=66666.6667
Rx3_Rfb_94 x3_Rfb_n94 x3_Rfb_n95 GND_LOGIC ppolyf_u R=66666.6667
Rx3_Rfb_95 x3_Rfb_n95 x3_Rfb_n96 GND_LOGIC ppolyf_u R=66666.6667
Rx3_Rfb_96 x3_Rfb_n96 x3_Rfb_n97 GND_LOGIC ppolyf_u R=66666.6667
Rx3_Rfb_97 x3_Rfb_n97 x3_Rfb_n98 GND_LOGIC ppolyf_u R=66666.6667
Rx3_Rfb_98 x3_Rfb_n98 x3_Rfb_n99 GND_LOGIC ppolyf_u R=66666.6667
Rx3_Rfb_99 x3_Rfb_n99 x3_Rfb_n100 GND_LOGIC ppolyf_u R=66666.6667
Rx3_Rref_0 VDD_DRV x3_Rref_n1 GND_LOGIC ppolyf_u R=66666.6667
Rx3_Rref_1 x3_Rref_n1 x3_Rref_n2 GND_LOGIC ppolyf_u R=66666.6667
Rx3_Rref_10 x3_Rref_n10 x3_Rref_n11 GND_LOGIC ppolyf_u R=66666.6667
Rx3_Rref_11 x3_Rref_n11 x3_nref GND_LOGIC ppolyf_u R=66666.6667
Rx3_Rref_2 x3_Rref_n2 x3_Rref_n3 GND_LOGIC ppolyf_u R=66666.6667
Rx3_Rref_3 x3_Rref_n3 x3_Rref_n4 GND_LOGIC ppolyf_u R=66666.6667
Rx3_Rref_4 x3_Rref_n4 x3_Rref_n5 GND_LOGIC ppolyf_u R=66666.6667
Rx3_Rref_5 x3_Rref_n5 x3_Rref_n6 GND_LOGIC ppolyf_u R=66666.6667
Rx3_Rref_6 x3_Rref_n6 x3_Rref_n7 GND_LOGIC ppolyf_u R=66666.6667
Rx3_Rref_7 x3_Rref_n7 x3_Rref_n8 GND_LOGIC ppolyf_u R=66666.6667
Rx3_Rref_8 x3_Rref_n8 x3_Rref_n9 GND_LOGIC ppolyf_u R=66666.6667
Rx3_Rref_9 x3_Rref_n9 x3_Rref_n10 GND_LOGIC ppolyf_u R=66666.6667
.ENDS gate_driver_core
