* LVS reference netlist for gate_driver_core -- GENERATED, do not edit.
*
* Produced by layout/lvs/make_reference.py from
* design/netlist/gate_driver_core.spice via
* layout/gen_gate_driver_core.py's own parse_netlist_full(), applying the
* six mechanical transforms documented in that script's module docstring.
*
* MOS devices: 299 nfet + 660 pfet (24 schematic instances, expanded to drawn finger count)
* MiM caps  : 4 (4 schematic instances, 1:1 -- one drawn plate pair each)

.SUBCKT gate_driver_core GND_DRV|GND_LOGIC IN IN_DRV OUT VDD_DRV VDD_LOGIC x1_inb x1_na x1_nb x1_nbuf1 x1_nca x1_ncb x2_n1 x2_n2 x2_n3 x2_n4 x2_n5
Cx1_XCCOMP1 x1_ncb x1_nccomp1 cap_mim_2f0_m4m5_noshield C=5.4516e-14
Cx1_XCCOMP2 x1_nccomp1 x1_nccomp2 cap_mim_2f0_m4m5_noshield C=5.4516e-14
Cx1_XCCOMP3 x1_nccomp2 x1_nccomp3 cap_mim_2f0_m4m5_noshield C=5.4516e-14
Cx1_XCCOMP4 x1_nccomp3 IN_DRV cap_mim_2f0_m4m5_noshield C=5.4516e-14
Mx1_XMNBUF1_0 x1_nbuf1 x1_ncb GND_DRV|GND_LOGIC GND_DRV|GND_LOGIC nfet L=0.7U W=5U
Mx1_XMNBUF2_0 IN_DRV x1_nbuf1 GND_DRV|GND_LOGIC GND_DRV|GND_LOGIC nfet L=0.7U W=15U
Mx1_XMNCASA_0 x1_nca VDD_LOGIC x1_na GND_DRV|GND_LOGIC nfet L=0.7U W=20U
Mx1_XMNCASB_0 x1_ncb VDD_LOGIC x1_nb GND_DRV|GND_LOGIC nfet L=0.7U W=20U
Mx1_XMNINV_0 x1_inb IN GND_DRV|GND_LOGIC GND_DRV|GND_LOGIC nfet L=0.28U W=5U
Mx1_XMNPDA_0 x1_na IN GND_DRV|GND_LOGIC GND_DRV|GND_LOGIC nfet L=0.28U W=20U
Mx1_XMNPDB_0 x1_nb x1_inb GND_DRV|GND_LOGIC GND_DRV|GND_LOGIC nfet L=0.28U W=20U
Mx1_XMPBUF1_0 x1_nbuf1 x1_ncb VDD_DRV VDD_DRV pfet L=0.55U W=5U
Mx1_XMPBUF2_0 IN_DRV x1_nbuf1 VDD_DRV VDD_DRV pfet L=0.55U W=15U
Mx1_XMPINV_0 x1_inb IN VDD_LOGIC VDD_LOGIC pfet L=0.28U W=10U
Mx1_XMPLATA_0 x1_nca x1_ncb VDD_DRV VDD_DRV pfet L=0.55U W=3U
Mx1_XMPLATB_0 x1_ncb x1_nca VDD_DRV VDD_DRV pfet L=0.55U W=3U
Mx2_XMN1_0 x2_n1 IN_DRV GND_DRV|GND_LOGIC GND_DRV|GND_LOGIC nfet L=0.7U W=2U
Mx2_XMN2_0 x2_n2 x2_n1 GND_DRV|GND_LOGIC GND_DRV|GND_LOGIC nfet L=0.7U W=8U
Mx2_XMN3_0 x2_n3 x2_n2 GND_DRV|GND_LOGIC GND_DRV|GND_LOGIC nfet L=0.7U W=33U
Mx2_XMN4_0 x2_n4 x2_n3 GND_DRV|GND_LOGIC GND_DRV|GND_LOGIC nfet L=0.7U W=10U
Mx2_XMN4_1 x2_n4 x2_n3 GND_DRV|GND_LOGIC GND_DRV|GND_LOGIC nfet L=0.7U W=10U
Mx2_XMN4_10 x2_n4 x2_n3 GND_DRV|GND_LOGIC GND_DRV|GND_LOGIC nfet L=0.7U W=10U
Mx2_XMN4_11 x2_n4 x2_n3 GND_DRV|GND_LOGIC GND_DRV|GND_LOGIC nfet L=0.7U W=10U
Mx2_XMN4_12 x2_n4 x2_n3 GND_DRV|GND_LOGIC GND_DRV|GND_LOGIC nfet L=0.7U W=10U
Mx2_XMN4_13 x2_n4 x2_n3 GND_DRV|GND_LOGIC GND_DRV|GND_LOGIC nfet L=0.7U W=10U
Mx2_XMN4_2 x2_n4 x2_n3 GND_DRV|GND_LOGIC GND_DRV|GND_LOGIC nfet L=0.7U W=10U
Mx2_XMN4_3 x2_n4 x2_n3 GND_DRV|GND_LOGIC GND_DRV|GND_LOGIC nfet L=0.7U W=10U
Mx2_XMN4_4 x2_n4 x2_n3 GND_DRV|GND_LOGIC GND_DRV|GND_LOGIC nfet L=0.7U W=10U
Mx2_XMN4_5 x2_n4 x2_n3 GND_DRV|GND_LOGIC GND_DRV|GND_LOGIC nfet L=0.7U W=10U
Mx2_XMN4_6 x2_n4 x2_n3 GND_DRV|GND_LOGIC GND_DRV|GND_LOGIC nfet L=0.7U W=10U
Mx2_XMN4_7 x2_n4 x2_n3 GND_DRV|GND_LOGIC GND_DRV|GND_LOGIC nfet L=0.7U W=10U
Mx2_XMN4_8 x2_n4 x2_n3 GND_DRV|GND_LOGIC GND_DRV|GND_LOGIC nfet L=0.7U W=10U
Mx2_XMN4_9 x2_n4 x2_n3 GND_DRV|GND_LOGIC GND_DRV|GND_LOGIC nfet L=0.7U W=10U
Mx2_XMN5_0 x2_n5 x2_n4 GND_DRV|GND_LOGIC GND_DRV|GND_LOGIC nfet L=0.7U W=10U
Mx2_XMN5_1 x2_n5 x2_n4 GND_DRV|GND_LOGIC GND_DRV|GND_LOGIC nfet L=0.7U W=10U
Mx2_XMN5_10 x2_n5 x2_n4 GND_DRV|GND_LOGIC GND_DRV|GND_LOGIC nfet L=0.7U W=10U
Mx2_XMN5_11 x2_n5 x2_n4 GND_DRV|GND_LOGIC GND_DRV|GND_LOGIC nfet L=0.7U W=10U
Mx2_XMN5_12 x2_n5 x2_n4 GND_DRV|GND_LOGIC GND_DRV|GND_LOGIC nfet L=0.7U W=10U
Mx2_XMN5_13 x2_n5 x2_n4 GND_DRV|GND_LOGIC GND_DRV|GND_LOGIC nfet L=0.7U W=10U
Mx2_XMN5_14 x2_n5 x2_n4 GND_DRV|GND_LOGIC GND_DRV|GND_LOGIC nfet L=0.7U W=10U
Mx2_XMN5_15 x2_n5 x2_n4 GND_DRV|GND_LOGIC GND_DRV|GND_LOGIC nfet L=0.7U W=10U
Mx2_XMN5_16 x2_n5 x2_n4 GND_DRV|GND_LOGIC GND_DRV|GND_LOGIC nfet L=0.7U W=10U
Mx2_XMN5_17 x2_n5 x2_n4 GND_DRV|GND_LOGIC GND_DRV|GND_LOGIC nfet L=0.7U W=10U
Mx2_XMN5_18 x2_n5 x2_n4 GND_DRV|GND_LOGIC GND_DRV|GND_LOGIC nfet L=0.7U W=10U
Mx2_XMN5_19 x2_n5 x2_n4 GND_DRV|GND_LOGIC GND_DRV|GND_LOGIC nfet L=0.7U W=10U
Mx2_XMN5_2 x2_n5 x2_n4 GND_DRV|GND_LOGIC GND_DRV|GND_LOGIC nfet L=0.7U W=10U
Mx2_XMN5_20 x2_n5 x2_n4 GND_DRV|GND_LOGIC GND_DRV|GND_LOGIC nfet L=0.7U W=10U
Mx2_XMN5_21 x2_n5 x2_n4 GND_DRV|GND_LOGIC GND_DRV|GND_LOGIC nfet L=0.7U W=10U
Mx2_XMN5_22 x2_n5 x2_n4 GND_DRV|GND_LOGIC GND_DRV|GND_LOGIC nfet L=0.7U W=10U
Mx2_XMN5_23 x2_n5 x2_n4 GND_DRV|GND_LOGIC GND_DRV|GND_LOGIC nfet L=0.7U W=10U
Mx2_XMN5_24 x2_n5 x2_n4 GND_DRV|GND_LOGIC GND_DRV|GND_LOGIC nfet L=0.7U W=10U
Mx2_XMN5_25 x2_n5 x2_n4 GND_DRV|GND_LOGIC GND_DRV|GND_LOGIC nfet L=0.7U W=10U
Mx2_XMN5_26 x2_n5 x2_n4 GND_DRV|GND_LOGIC GND_DRV|GND_LOGIC nfet L=0.7U W=10U
Mx2_XMN5_27 x2_n5 x2_n4 GND_DRV|GND_LOGIC GND_DRV|GND_LOGIC nfet L=0.7U W=10U
Mx2_XMN5_28 x2_n5 x2_n4 GND_DRV|GND_LOGIC GND_DRV|GND_LOGIC nfet L=0.7U W=10U
Mx2_XMN5_29 x2_n5 x2_n4 GND_DRV|GND_LOGIC GND_DRV|GND_LOGIC nfet L=0.7U W=10U
Mx2_XMN5_3 x2_n5 x2_n4 GND_DRV|GND_LOGIC GND_DRV|GND_LOGIC nfet L=0.7U W=10U
Mx2_XMN5_30 x2_n5 x2_n4 GND_DRV|GND_LOGIC GND_DRV|GND_LOGIC nfet L=0.7U W=10U
Mx2_XMN5_31 x2_n5 x2_n4 GND_DRV|GND_LOGIC GND_DRV|GND_LOGIC nfet L=0.7U W=10U
Mx2_XMN5_32 x2_n5 x2_n4 GND_DRV|GND_LOGIC GND_DRV|GND_LOGIC nfet L=0.7U W=10U
Mx2_XMN5_33 x2_n5 x2_n4 GND_DRV|GND_LOGIC GND_DRV|GND_LOGIC nfet L=0.7U W=10U
Mx2_XMN5_34 x2_n5 x2_n4 GND_DRV|GND_LOGIC GND_DRV|GND_LOGIC nfet L=0.7U W=10U
Mx2_XMN5_35 x2_n5 x2_n4 GND_DRV|GND_LOGIC GND_DRV|GND_LOGIC nfet L=0.7U W=10U
Mx2_XMN5_36 x2_n5 x2_n4 GND_DRV|GND_LOGIC GND_DRV|GND_LOGIC nfet L=0.7U W=10U
Mx2_XMN5_37 x2_n5 x2_n4 GND_DRV|GND_LOGIC GND_DRV|GND_LOGIC nfet L=0.7U W=10U
Mx2_XMN5_38 x2_n5 x2_n4 GND_DRV|GND_LOGIC GND_DRV|GND_LOGIC nfet L=0.7U W=10U
Mx2_XMN5_39 x2_n5 x2_n4 GND_DRV|GND_LOGIC GND_DRV|GND_LOGIC nfet L=0.7U W=10U
Mx2_XMN5_4 x2_n5 x2_n4 GND_DRV|GND_LOGIC GND_DRV|GND_LOGIC nfet L=0.7U W=10U
Mx2_XMN5_40 x2_n5 x2_n4 GND_DRV|GND_LOGIC GND_DRV|GND_LOGIC nfet L=0.7U W=10U
Mx2_XMN5_41 x2_n5 x2_n4 GND_DRV|GND_LOGIC GND_DRV|GND_LOGIC nfet L=0.7U W=10U
Mx2_XMN5_42 x2_n5 x2_n4 GND_DRV|GND_LOGIC GND_DRV|GND_LOGIC nfet L=0.7U W=10U
Mx2_XMN5_43 x2_n5 x2_n4 GND_DRV|GND_LOGIC GND_DRV|GND_LOGIC nfet L=0.7U W=10U
Mx2_XMN5_44 x2_n5 x2_n4 GND_DRV|GND_LOGIC GND_DRV|GND_LOGIC nfet L=0.7U W=10U
Mx2_XMN5_45 x2_n5 x2_n4 GND_DRV|GND_LOGIC GND_DRV|GND_LOGIC nfet L=0.7U W=10U
Mx2_XMN5_46 x2_n5 x2_n4 GND_DRV|GND_LOGIC GND_DRV|GND_LOGIC nfet L=0.7U W=10U
Mx2_XMN5_47 x2_n5 x2_n4 GND_DRV|GND_LOGIC GND_DRV|GND_LOGIC nfet L=0.7U W=10U
Mx2_XMN5_48 x2_n5 x2_n4 GND_DRV|GND_LOGIC GND_DRV|GND_LOGIC nfet L=0.7U W=10U
Mx2_XMN5_49 x2_n5 x2_n4 GND_DRV|GND_LOGIC GND_DRV|GND_LOGIC nfet L=0.7U W=10U
Mx2_XMN5_5 x2_n5 x2_n4 GND_DRV|GND_LOGIC GND_DRV|GND_LOGIC nfet L=0.7U W=10U
Mx2_XMN5_50 x2_n5 x2_n4 GND_DRV|GND_LOGIC GND_DRV|GND_LOGIC nfet L=0.7U W=10U
Mx2_XMN5_51 x2_n5 x2_n4 GND_DRV|GND_LOGIC GND_DRV|GND_LOGIC nfet L=0.7U W=10U
Mx2_XMN5_52 x2_n5 x2_n4 GND_DRV|GND_LOGIC GND_DRV|GND_LOGIC nfet L=0.7U W=10U
Mx2_XMN5_53 x2_n5 x2_n4 GND_DRV|GND_LOGIC GND_DRV|GND_LOGIC nfet L=0.7U W=10U
Mx2_XMN5_54 x2_n5 x2_n4 GND_DRV|GND_LOGIC GND_DRV|GND_LOGIC nfet L=0.7U W=10U
Mx2_XMN5_6 x2_n5 x2_n4 GND_DRV|GND_LOGIC GND_DRV|GND_LOGIC nfet L=0.7U W=10U
Mx2_XMN5_7 x2_n5 x2_n4 GND_DRV|GND_LOGIC GND_DRV|GND_LOGIC nfet L=0.7U W=10U
Mx2_XMN5_8 x2_n5 x2_n4 GND_DRV|GND_LOGIC GND_DRV|GND_LOGIC nfet L=0.7U W=10U
Mx2_XMN5_9 x2_n5 x2_n4 GND_DRV|GND_LOGIC GND_DRV|GND_LOGIC nfet L=0.7U W=10U
Mx2_XMN6_0 OUT x2_n5 GND_DRV|GND_LOGIC GND_DRV|GND_LOGIC nfet L=0.7U W=10U
Mx2_XMN6_1 OUT x2_n5 GND_DRV|GND_LOGIC GND_DRV|GND_LOGIC nfet L=0.7U W=10U
Mx2_XMN6_10 OUT x2_n5 GND_DRV|GND_LOGIC GND_DRV|GND_LOGIC nfet L=0.7U W=10U
Mx2_XMN6_100 OUT x2_n5 GND_DRV|GND_LOGIC GND_DRV|GND_LOGIC nfet L=0.7U W=10U
Mx2_XMN6_101 OUT x2_n5 GND_DRV|GND_LOGIC GND_DRV|GND_LOGIC nfet L=0.7U W=10U
Mx2_XMN6_102 OUT x2_n5 GND_DRV|GND_LOGIC GND_DRV|GND_LOGIC nfet L=0.7U W=10U
Mx2_XMN6_103 OUT x2_n5 GND_DRV|GND_LOGIC GND_DRV|GND_LOGIC nfet L=0.7U W=10U
Mx2_XMN6_104 OUT x2_n5 GND_DRV|GND_LOGIC GND_DRV|GND_LOGIC nfet L=0.7U W=10U
Mx2_XMN6_105 OUT x2_n5 GND_DRV|GND_LOGIC GND_DRV|GND_LOGIC nfet L=0.7U W=10U
Mx2_XMN6_106 OUT x2_n5 GND_DRV|GND_LOGIC GND_DRV|GND_LOGIC nfet L=0.7U W=10U
Mx2_XMN6_107 OUT x2_n5 GND_DRV|GND_LOGIC GND_DRV|GND_LOGIC nfet L=0.7U W=10U
Mx2_XMN6_108 OUT x2_n5 GND_DRV|GND_LOGIC GND_DRV|GND_LOGIC nfet L=0.7U W=10U
Mx2_XMN6_109 OUT x2_n5 GND_DRV|GND_LOGIC GND_DRV|GND_LOGIC nfet L=0.7U W=10U
Mx2_XMN6_11 OUT x2_n5 GND_DRV|GND_LOGIC GND_DRV|GND_LOGIC nfet L=0.7U W=10U
Mx2_XMN6_110 OUT x2_n5 GND_DRV|GND_LOGIC GND_DRV|GND_LOGIC nfet L=0.7U W=10U
Mx2_XMN6_111 OUT x2_n5 GND_DRV|GND_LOGIC GND_DRV|GND_LOGIC nfet L=0.7U W=10U
Mx2_XMN6_112 OUT x2_n5 GND_DRV|GND_LOGIC GND_DRV|GND_LOGIC nfet L=0.7U W=10U
Mx2_XMN6_113 OUT x2_n5 GND_DRV|GND_LOGIC GND_DRV|GND_LOGIC nfet L=0.7U W=10U
Mx2_XMN6_114 OUT x2_n5 GND_DRV|GND_LOGIC GND_DRV|GND_LOGIC nfet L=0.7U W=10U
Mx2_XMN6_115 OUT x2_n5 GND_DRV|GND_LOGIC GND_DRV|GND_LOGIC nfet L=0.7U W=10U
Mx2_XMN6_116 OUT x2_n5 GND_DRV|GND_LOGIC GND_DRV|GND_LOGIC nfet L=0.7U W=10U
Mx2_XMN6_117 OUT x2_n5 GND_DRV|GND_LOGIC GND_DRV|GND_LOGIC nfet L=0.7U W=10U
Mx2_XMN6_118 OUT x2_n5 GND_DRV|GND_LOGIC GND_DRV|GND_LOGIC nfet L=0.7U W=10U
Mx2_XMN6_119 OUT x2_n5 GND_DRV|GND_LOGIC GND_DRV|GND_LOGIC nfet L=0.7U W=10U
Mx2_XMN6_12 OUT x2_n5 GND_DRV|GND_LOGIC GND_DRV|GND_LOGIC nfet L=0.7U W=10U
Mx2_XMN6_120 OUT x2_n5 GND_DRV|GND_LOGIC GND_DRV|GND_LOGIC nfet L=0.7U W=10U
Mx2_XMN6_121 OUT x2_n5 GND_DRV|GND_LOGIC GND_DRV|GND_LOGIC nfet L=0.7U W=10U
Mx2_XMN6_122 OUT x2_n5 GND_DRV|GND_LOGIC GND_DRV|GND_LOGIC nfet L=0.7U W=10U
Mx2_XMN6_123 OUT x2_n5 GND_DRV|GND_LOGIC GND_DRV|GND_LOGIC nfet L=0.7U W=10U
Mx2_XMN6_124 OUT x2_n5 GND_DRV|GND_LOGIC GND_DRV|GND_LOGIC nfet L=0.7U W=10U
Mx2_XMN6_125 OUT x2_n5 GND_DRV|GND_LOGIC GND_DRV|GND_LOGIC nfet L=0.7U W=10U
Mx2_XMN6_126 OUT x2_n5 GND_DRV|GND_LOGIC GND_DRV|GND_LOGIC nfet L=0.7U W=10U
Mx2_XMN6_127 OUT x2_n5 GND_DRV|GND_LOGIC GND_DRV|GND_LOGIC nfet L=0.7U W=10U
Mx2_XMN6_128 OUT x2_n5 GND_DRV|GND_LOGIC GND_DRV|GND_LOGIC nfet L=0.7U W=10U
Mx2_XMN6_129 OUT x2_n5 GND_DRV|GND_LOGIC GND_DRV|GND_LOGIC nfet L=0.7U W=10U
Mx2_XMN6_13 OUT x2_n5 GND_DRV|GND_LOGIC GND_DRV|GND_LOGIC nfet L=0.7U W=10U
Mx2_XMN6_130 OUT x2_n5 GND_DRV|GND_LOGIC GND_DRV|GND_LOGIC nfet L=0.7U W=10U
Mx2_XMN6_131 OUT x2_n5 GND_DRV|GND_LOGIC GND_DRV|GND_LOGIC nfet L=0.7U W=10U
Mx2_XMN6_132 OUT x2_n5 GND_DRV|GND_LOGIC GND_DRV|GND_LOGIC nfet L=0.7U W=10U
Mx2_XMN6_133 OUT x2_n5 GND_DRV|GND_LOGIC GND_DRV|GND_LOGIC nfet L=0.7U W=10U
Mx2_XMN6_134 OUT x2_n5 GND_DRV|GND_LOGIC GND_DRV|GND_LOGIC nfet L=0.7U W=10U
Mx2_XMN6_135 OUT x2_n5 GND_DRV|GND_LOGIC GND_DRV|GND_LOGIC nfet L=0.7U W=10U
Mx2_XMN6_136 OUT x2_n5 GND_DRV|GND_LOGIC GND_DRV|GND_LOGIC nfet L=0.7U W=10U
Mx2_XMN6_137 OUT x2_n5 GND_DRV|GND_LOGIC GND_DRV|GND_LOGIC nfet L=0.7U W=10U
Mx2_XMN6_138 OUT x2_n5 GND_DRV|GND_LOGIC GND_DRV|GND_LOGIC nfet L=0.7U W=10U
Mx2_XMN6_139 OUT x2_n5 GND_DRV|GND_LOGIC GND_DRV|GND_LOGIC nfet L=0.7U W=10U
Mx2_XMN6_14 OUT x2_n5 GND_DRV|GND_LOGIC GND_DRV|GND_LOGIC nfet L=0.7U W=10U
Mx2_XMN6_140 OUT x2_n5 GND_DRV|GND_LOGIC GND_DRV|GND_LOGIC nfet L=0.7U W=10U
Mx2_XMN6_141 OUT x2_n5 GND_DRV|GND_LOGIC GND_DRV|GND_LOGIC nfet L=0.7U W=10U
Mx2_XMN6_142 OUT x2_n5 GND_DRV|GND_LOGIC GND_DRV|GND_LOGIC nfet L=0.7U W=10U
Mx2_XMN6_143 OUT x2_n5 GND_DRV|GND_LOGIC GND_DRV|GND_LOGIC nfet L=0.7U W=10U
Mx2_XMN6_144 OUT x2_n5 GND_DRV|GND_LOGIC GND_DRV|GND_LOGIC nfet L=0.7U W=10U
Mx2_XMN6_145 OUT x2_n5 GND_DRV|GND_LOGIC GND_DRV|GND_LOGIC nfet L=0.7U W=10U
Mx2_XMN6_146 OUT x2_n5 GND_DRV|GND_LOGIC GND_DRV|GND_LOGIC nfet L=0.7U W=10U
Mx2_XMN6_147 OUT x2_n5 GND_DRV|GND_LOGIC GND_DRV|GND_LOGIC nfet L=0.7U W=10U
Mx2_XMN6_148 OUT x2_n5 GND_DRV|GND_LOGIC GND_DRV|GND_LOGIC nfet L=0.7U W=10U
Mx2_XMN6_149 OUT x2_n5 GND_DRV|GND_LOGIC GND_DRV|GND_LOGIC nfet L=0.7U W=10U
Mx2_XMN6_15 OUT x2_n5 GND_DRV|GND_LOGIC GND_DRV|GND_LOGIC nfet L=0.7U W=10U
Mx2_XMN6_150 OUT x2_n5 GND_DRV|GND_LOGIC GND_DRV|GND_LOGIC nfet L=0.7U W=10U
Mx2_XMN6_151 OUT x2_n5 GND_DRV|GND_LOGIC GND_DRV|GND_LOGIC nfet L=0.7U W=10U
Mx2_XMN6_152 OUT x2_n5 GND_DRV|GND_LOGIC GND_DRV|GND_LOGIC nfet L=0.7U W=10U
Mx2_XMN6_153 OUT x2_n5 GND_DRV|GND_LOGIC GND_DRV|GND_LOGIC nfet L=0.7U W=10U
Mx2_XMN6_154 OUT x2_n5 GND_DRV|GND_LOGIC GND_DRV|GND_LOGIC nfet L=0.7U W=10U
Mx2_XMN6_155 OUT x2_n5 GND_DRV|GND_LOGIC GND_DRV|GND_LOGIC nfet L=0.7U W=10U
Mx2_XMN6_156 OUT x2_n5 GND_DRV|GND_LOGIC GND_DRV|GND_LOGIC nfet L=0.7U W=10U
Mx2_XMN6_157 OUT x2_n5 GND_DRV|GND_LOGIC GND_DRV|GND_LOGIC nfet L=0.7U W=10U
Mx2_XMN6_158 OUT x2_n5 GND_DRV|GND_LOGIC GND_DRV|GND_LOGIC nfet L=0.7U W=10U
Mx2_XMN6_159 OUT x2_n5 GND_DRV|GND_LOGIC GND_DRV|GND_LOGIC nfet L=0.7U W=10U
Mx2_XMN6_16 OUT x2_n5 GND_DRV|GND_LOGIC GND_DRV|GND_LOGIC nfet L=0.7U W=10U
Mx2_XMN6_160 OUT x2_n5 GND_DRV|GND_LOGIC GND_DRV|GND_LOGIC nfet L=0.7U W=10U
Mx2_XMN6_161 OUT x2_n5 GND_DRV|GND_LOGIC GND_DRV|GND_LOGIC nfet L=0.7U W=10U
Mx2_XMN6_162 OUT x2_n5 GND_DRV|GND_LOGIC GND_DRV|GND_LOGIC nfet L=0.7U W=10U
Mx2_XMN6_163 OUT x2_n5 GND_DRV|GND_LOGIC GND_DRV|GND_LOGIC nfet L=0.7U W=10U
Mx2_XMN6_164 OUT x2_n5 GND_DRV|GND_LOGIC GND_DRV|GND_LOGIC nfet L=0.7U W=10U
Mx2_XMN6_165 OUT x2_n5 GND_DRV|GND_LOGIC GND_DRV|GND_LOGIC nfet L=0.7U W=10U
Mx2_XMN6_166 OUT x2_n5 GND_DRV|GND_LOGIC GND_DRV|GND_LOGIC nfet L=0.7U W=10U
Mx2_XMN6_167 OUT x2_n5 GND_DRV|GND_LOGIC GND_DRV|GND_LOGIC nfet L=0.7U W=10U
Mx2_XMN6_168 OUT x2_n5 GND_DRV|GND_LOGIC GND_DRV|GND_LOGIC nfet L=0.7U W=10U
Mx2_XMN6_169 OUT x2_n5 GND_DRV|GND_LOGIC GND_DRV|GND_LOGIC nfet L=0.7U W=10U
Mx2_XMN6_17 OUT x2_n5 GND_DRV|GND_LOGIC GND_DRV|GND_LOGIC nfet L=0.7U W=10U
Mx2_XMN6_170 OUT x2_n5 GND_DRV|GND_LOGIC GND_DRV|GND_LOGIC nfet L=0.7U W=10U
Mx2_XMN6_171 OUT x2_n5 GND_DRV|GND_LOGIC GND_DRV|GND_LOGIC nfet L=0.7U W=10U
Mx2_XMN6_172 OUT x2_n5 GND_DRV|GND_LOGIC GND_DRV|GND_LOGIC nfet L=0.7U W=10U
Mx2_XMN6_173 OUT x2_n5 GND_DRV|GND_LOGIC GND_DRV|GND_LOGIC nfet L=0.7U W=10U
Mx2_XMN6_174 OUT x2_n5 GND_DRV|GND_LOGIC GND_DRV|GND_LOGIC nfet L=0.7U W=10U
Mx2_XMN6_175 OUT x2_n5 GND_DRV|GND_LOGIC GND_DRV|GND_LOGIC nfet L=0.7U W=10U
Mx2_XMN6_176 OUT x2_n5 GND_DRV|GND_LOGIC GND_DRV|GND_LOGIC nfet L=0.7U W=10U
Mx2_XMN6_177 OUT x2_n5 GND_DRV|GND_LOGIC GND_DRV|GND_LOGIC nfet L=0.7U W=10U
Mx2_XMN6_178 OUT x2_n5 GND_DRV|GND_LOGIC GND_DRV|GND_LOGIC nfet L=0.7U W=10U
Mx2_XMN6_179 OUT x2_n5 GND_DRV|GND_LOGIC GND_DRV|GND_LOGIC nfet L=0.7U W=10U
Mx2_XMN6_18 OUT x2_n5 GND_DRV|GND_LOGIC GND_DRV|GND_LOGIC nfet L=0.7U W=10U
Mx2_XMN6_180 OUT x2_n5 GND_DRV|GND_LOGIC GND_DRV|GND_LOGIC nfet L=0.7U W=10U
Mx2_XMN6_181 OUT x2_n5 GND_DRV|GND_LOGIC GND_DRV|GND_LOGIC nfet L=0.7U W=10U
Mx2_XMN6_182 OUT x2_n5 GND_DRV|GND_LOGIC GND_DRV|GND_LOGIC nfet L=0.7U W=10U
Mx2_XMN6_183 OUT x2_n5 GND_DRV|GND_LOGIC GND_DRV|GND_LOGIC nfet L=0.7U W=10U
Mx2_XMN6_184 OUT x2_n5 GND_DRV|GND_LOGIC GND_DRV|GND_LOGIC nfet L=0.7U W=10U
Mx2_XMN6_185 OUT x2_n5 GND_DRV|GND_LOGIC GND_DRV|GND_LOGIC nfet L=0.7U W=10U
Mx2_XMN6_186 OUT x2_n5 GND_DRV|GND_LOGIC GND_DRV|GND_LOGIC nfet L=0.7U W=10U
Mx2_XMN6_187 OUT x2_n5 GND_DRV|GND_LOGIC GND_DRV|GND_LOGIC nfet L=0.7U W=10U
Mx2_XMN6_188 OUT x2_n5 GND_DRV|GND_LOGIC GND_DRV|GND_LOGIC nfet L=0.7U W=10U
Mx2_XMN6_189 OUT x2_n5 GND_DRV|GND_LOGIC GND_DRV|GND_LOGIC nfet L=0.7U W=10U
Mx2_XMN6_19 OUT x2_n5 GND_DRV|GND_LOGIC GND_DRV|GND_LOGIC nfet L=0.7U W=10U
Mx2_XMN6_190 OUT x2_n5 GND_DRV|GND_LOGIC GND_DRV|GND_LOGIC nfet L=0.7U W=10U
Mx2_XMN6_191 OUT x2_n5 GND_DRV|GND_LOGIC GND_DRV|GND_LOGIC nfet L=0.7U W=10U
Mx2_XMN6_192 OUT x2_n5 GND_DRV|GND_LOGIC GND_DRV|GND_LOGIC nfet L=0.7U W=10U
Mx2_XMN6_193 OUT x2_n5 GND_DRV|GND_LOGIC GND_DRV|GND_LOGIC nfet L=0.7U W=10U
Mx2_XMN6_194 OUT x2_n5 GND_DRV|GND_LOGIC GND_DRV|GND_LOGIC nfet L=0.7U W=10U
Mx2_XMN6_195 OUT x2_n5 GND_DRV|GND_LOGIC GND_DRV|GND_LOGIC nfet L=0.7U W=10U
Mx2_XMN6_196 OUT x2_n5 GND_DRV|GND_LOGIC GND_DRV|GND_LOGIC nfet L=0.7U W=10U
Mx2_XMN6_197 OUT x2_n5 GND_DRV|GND_LOGIC GND_DRV|GND_LOGIC nfet L=0.7U W=10U
Mx2_XMN6_198 OUT x2_n5 GND_DRV|GND_LOGIC GND_DRV|GND_LOGIC nfet L=0.7U W=10U
Mx2_XMN6_199 OUT x2_n5 GND_DRV|GND_LOGIC GND_DRV|GND_LOGIC nfet L=0.7U W=10U
Mx2_XMN6_2 OUT x2_n5 GND_DRV|GND_LOGIC GND_DRV|GND_LOGIC nfet L=0.7U W=10U
Mx2_XMN6_20 OUT x2_n5 GND_DRV|GND_LOGIC GND_DRV|GND_LOGIC nfet L=0.7U W=10U
Mx2_XMN6_200 OUT x2_n5 GND_DRV|GND_LOGIC GND_DRV|GND_LOGIC nfet L=0.7U W=10U
Mx2_XMN6_201 OUT x2_n5 GND_DRV|GND_LOGIC GND_DRV|GND_LOGIC nfet L=0.7U W=10U
Mx2_XMN6_202 OUT x2_n5 GND_DRV|GND_LOGIC GND_DRV|GND_LOGIC nfet L=0.7U W=10U
Mx2_XMN6_203 OUT x2_n5 GND_DRV|GND_LOGIC GND_DRV|GND_LOGIC nfet L=0.7U W=10U
Mx2_XMN6_204 OUT x2_n5 GND_DRV|GND_LOGIC GND_DRV|GND_LOGIC nfet L=0.7U W=10U
Mx2_XMN6_205 OUT x2_n5 GND_DRV|GND_LOGIC GND_DRV|GND_LOGIC nfet L=0.7U W=10U
Mx2_XMN6_206 OUT x2_n5 GND_DRV|GND_LOGIC GND_DRV|GND_LOGIC nfet L=0.7U W=10U
Mx2_XMN6_207 OUT x2_n5 GND_DRV|GND_LOGIC GND_DRV|GND_LOGIC nfet L=0.7U W=10U
Mx2_XMN6_208 OUT x2_n5 GND_DRV|GND_LOGIC GND_DRV|GND_LOGIC nfet L=0.7U W=10U
Mx2_XMN6_209 OUT x2_n5 GND_DRV|GND_LOGIC GND_DRV|GND_LOGIC nfet L=0.7U W=10U
Mx2_XMN6_21 OUT x2_n5 GND_DRV|GND_LOGIC GND_DRV|GND_LOGIC nfet L=0.7U W=10U
Mx2_XMN6_210 OUT x2_n5 GND_DRV|GND_LOGIC GND_DRV|GND_LOGIC nfet L=0.7U W=10U
Mx2_XMN6_211 OUT x2_n5 GND_DRV|GND_LOGIC GND_DRV|GND_LOGIC nfet L=0.7U W=10U
Mx2_XMN6_212 OUT x2_n5 GND_DRV|GND_LOGIC GND_DRV|GND_LOGIC nfet L=0.7U W=10U
Mx2_XMN6_213 OUT x2_n5 GND_DRV|GND_LOGIC GND_DRV|GND_LOGIC nfet L=0.7U W=10U
Mx2_XMN6_214 OUT x2_n5 GND_DRV|GND_LOGIC GND_DRV|GND_LOGIC nfet L=0.7U W=10U
Mx2_XMN6_215 OUT x2_n5 GND_DRV|GND_LOGIC GND_DRV|GND_LOGIC nfet L=0.7U W=10U
Mx2_XMN6_216 OUT x2_n5 GND_DRV|GND_LOGIC GND_DRV|GND_LOGIC nfet L=0.7U W=10U
Mx2_XMN6_217 OUT x2_n5 GND_DRV|GND_LOGIC GND_DRV|GND_LOGIC nfet L=0.7U W=10U
Mx2_XMN6_218 OUT x2_n5 GND_DRV|GND_LOGIC GND_DRV|GND_LOGIC nfet L=0.7U W=10U
Mx2_XMN6_219 OUT x2_n5 GND_DRV|GND_LOGIC GND_DRV|GND_LOGIC nfet L=0.7U W=10U
Mx2_XMN6_22 OUT x2_n5 GND_DRV|GND_LOGIC GND_DRV|GND_LOGIC nfet L=0.7U W=10U
Mx2_XMN6_23 OUT x2_n5 GND_DRV|GND_LOGIC GND_DRV|GND_LOGIC nfet L=0.7U W=10U
Mx2_XMN6_24 OUT x2_n5 GND_DRV|GND_LOGIC GND_DRV|GND_LOGIC nfet L=0.7U W=10U
Mx2_XMN6_25 OUT x2_n5 GND_DRV|GND_LOGIC GND_DRV|GND_LOGIC nfet L=0.7U W=10U
Mx2_XMN6_26 OUT x2_n5 GND_DRV|GND_LOGIC GND_DRV|GND_LOGIC nfet L=0.7U W=10U
Mx2_XMN6_27 OUT x2_n5 GND_DRV|GND_LOGIC GND_DRV|GND_LOGIC nfet L=0.7U W=10U
Mx2_XMN6_28 OUT x2_n5 GND_DRV|GND_LOGIC GND_DRV|GND_LOGIC nfet L=0.7U W=10U
Mx2_XMN6_29 OUT x2_n5 GND_DRV|GND_LOGIC GND_DRV|GND_LOGIC nfet L=0.7U W=10U
Mx2_XMN6_3 OUT x2_n5 GND_DRV|GND_LOGIC GND_DRV|GND_LOGIC nfet L=0.7U W=10U
Mx2_XMN6_30 OUT x2_n5 GND_DRV|GND_LOGIC GND_DRV|GND_LOGIC nfet L=0.7U W=10U
Mx2_XMN6_31 OUT x2_n5 GND_DRV|GND_LOGIC GND_DRV|GND_LOGIC nfet L=0.7U W=10U
Mx2_XMN6_32 OUT x2_n5 GND_DRV|GND_LOGIC GND_DRV|GND_LOGIC nfet L=0.7U W=10U
Mx2_XMN6_33 OUT x2_n5 GND_DRV|GND_LOGIC GND_DRV|GND_LOGIC nfet L=0.7U W=10U
Mx2_XMN6_34 OUT x2_n5 GND_DRV|GND_LOGIC GND_DRV|GND_LOGIC nfet L=0.7U W=10U
Mx2_XMN6_35 OUT x2_n5 GND_DRV|GND_LOGIC GND_DRV|GND_LOGIC nfet L=0.7U W=10U
Mx2_XMN6_36 OUT x2_n5 GND_DRV|GND_LOGIC GND_DRV|GND_LOGIC nfet L=0.7U W=10U
Mx2_XMN6_37 OUT x2_n5 GND_DRV|GND_LOGIC GND_DRV|GND_LOGIC nfet L=0.7U W=10U
Mx2_XMN6_38 OUT x2_n5 GND_DRV|GND_LOGIC GND_DRV|GND_LOGIC nfet L=0.7U W=10U
Mx2_XMN6_39 OUT x2_n5 GND_DRV|GND_LOGIC GND_DRV|GND_LOGIC nfet L=0.7U W=10U
Mx2_XMN6_4 OUT x2_n5 GND_DRV|GND_LOGIC GND_DRV|GND_LOGIC nfet L=0.7U W=10U
Mx2_XMN6_40 OUT x2_n5 GND_DRV|GND_LOGIC GND_DRV|GND_LOGIC nfet L=0.7U W=10U
Mx2_XMN6_41 OUT x2_n5 GND_DRV|GND_LOGIC GND_DRV|GND_LOGIC nfet L=0.7U W=10U
Mx2_XMN6_42 OUT x2_n5 GND_DRV|GND_LOGIC GND_DRV|GND_LOGIC nfet L=0.7U W=10U
Mx2_XMN6_43 OUT x2_n5 GND_DRV|GND_LOGIC GND_DRV|GND_LOGIC nfet L=0.7U W=10U
Mx2_XMN6_44 OUT x2_n5 GND_DRV|GND_LOGIC GND_DRV|GND_LOGIC nfet L=0.7U W=10U
Mx2_XMN6_45 OUT x2_n5 GND_DRV|GND_LOGIC GND_DRV|GND_LOGIC nfet L=0.7U W=10U
Mx2_XMN6_46 OUT x2_n5 GND_DRV|GND_LOGIC GND_DRV|GND_LOGIC nfet L=0.7U W=10U
Mx2_XMN6_47 OUT x2_n5 GND_DRV|GND_LOGIC GND_DRV|GND_LOGIC nfet L=0.7U W=10U
Mx2_XMN6_48 OUT x2_n5 GND_DRV|GND_LOGIC GND_DRV|GND_LOGIC nfet L=0.7U W=10U
Mx2_XMN6_49 OUT x2_n5 GND_DRV|GND_LOGIC GND_DRV|GND_LOGIC nfet L=0.7U W=10U
Mx2_XMN6_5 OUT x2_n5 GND_DRV|GND_LOGIC GND_DRV|GND_LOGIC nfet L=0.7U W=10U
Mx2_XMN6_50 OUT x2_n5 GND_DRV|GND_LOGIC GND_DRV|GND_LOGIC nfet L=0.7U W=10U
Mx2_XMN6_51 OUT x2_n5 GND_DRV|GND_LOGIC GND_DRV|GND_LOGIC nfet L=0.7U W=10U
Mx2_XMN6_52 OUT x2_n5 GND_DRV|GND_LOGIC GND_DRV|GND_LOGIC nfet L=0.7U W=10U
Mx2_XMN6_53 OUT x2_n5 GND_DRV|GND_LOGIC GND_DRV|GND_LOGIC nfet L=0.7U W=10U
Mx2_XMN6_54 OUT x2_n5 GND_DRV|GND_LOGIC GND_DRV|GND_LOGIC nfet L=0.7U W=10U
Mx2_XMN6_55 OUT x2_n5 GND_DRV|GND_LOGIC GND_DRV|GND_LOGIC nfet L=0.7U W=10U
Mx2_XMN6_56 OUT x2_n5 GND_DRV|GND_LOGIC GND_DRV|GND_LOGIC nfet L=0.7U W=10U
Mx2_XMN6_57 OUT x2_n5 GND_DRV|GND_LOGIC GND_DRV|GND_LOGIC nfet L=0.7U W=10U
Mx2_XMN6_58 OUT x2_n5 GND_DRV|GND_LOGIC GND_DRV|GND_LOGIC nfet L=0.7U W=10U
Mx2_XMN6_59 OUT x2_n5 GND_DRV|GND_LOGIC GND_DRV|GND_LOGIC nfet L=0.7U W=10U
Mx2_XMN6_6 OUT x2_n5 GND_DRV|GND_LOGIC GND_DRV|GND_LOGIC nfet L=0.7U W=10U
Mx2_XMN6_60 OUT x2_n5 GND_DRV|GND_LOGIC GND_DRV|GND_LOGIC nfet L=0.7U W=10U
Mx2_XMN6_61 OUT x2_n5 GND_DRV|GND_LOGIC GND_DRV|GND_LOGIC nfet L=0.7U W=10U
Mx2_XMN6_62 OUT x2_n5 GND_DRV|GND_LOGIC GND_DRV|GND_LOGIC nfet L=0.7U W=10U
Mx2_XMN6_63 OUT x2_n5 GND_DRV|GND_LOGIC GND_DRV|GND_LOGIC nfet L=0.7U W=10U
Mx2_XMN6_64 OUT x2_n5 GND_DRV|GND_LOGIC GND_DRV|GND_LOGIC nfet L=0.7U W=10U
Mx2_XMN6_65 OUT x2_n5 GND_DRV|GND_LOGIC GND_DRV|GND_LOGIC nfet L=0.7U W=10U
Mx2_XMN6_66 OUT x2_n5 GND_DRV|GND_LOGIC GND_DRV|GND_LOGIC nfet L=0.7U W=10U
Mx2_XMN6_67 OUT x2_n5 GND_DRV|GND_LOGIC GND_DRV|GND_LOGIC nfet L=0.7U W=10U
Mx2_XMN6_68 OUT x2_n5 GND_DRV|GND_LOGIC GND_DRV|GND_LOGIC nfet L=0.7U W=10U
Mx2_XMN6_69 OUT x2_n5 GND_DRV|GND_LOGIC GND_DRV|GND_LOGIC nfet L=0.7U W=10U
Mx2_XMN6_7 OUT x2_n5 GND_DRV|GND_LOGIC GND_DRV|GND_LOGIC nfet L=0.7U W=10U
Mx2_XMN6_70 OUT x2_n5 GND_DRV|GND_LOGIC GND_DRV|GND_LOGIC nfet L=0.7U W=10U
Mx2_XMN6_71 OUT x2_n5 GND_DRV|GND_LOGIC GND_DRV|GND_LOGIC nfet L=0.7U W=10U
Mx2_XMN6_72 OUT x2_n5 GND_DRV|GND_LOGIC GND_DRV|GND_LOGIC nfet L=0.7U W=10U
Mx2_XMN6_73 OUT x2_n5 GND_DRV|GND_LOGIC GND_DRV|GND_LOGIC nfet L=0.7U W=10U
Mx2_XMN6_74 OUT x2_n5 GND_DRV|GND_LOGIC GND_DRV|GND_LOGIC nfet L=0.7U W=10U
Mx2_XMN6_75 OUT x2_n5 GND_DRV|GND_LOGIC GND_DRV|GND_LOGIC nfet L=0.7U W=10U
Mx2_XMN6_76 OUT x2_n5 GND_DRV|GND_LOGIC GND_DRV|GND_LOGIC nfet L=0.7U W=10U
Mx2_XMN6_77 OUT x2_n5 GND_DRV|GND_LOGIC GND_DRV|GND_LOGIC nfet L=0.7U W=10U
Mx2_XMN6_78 OUT x2_n5 GND_DRV|GND_LOGIC GND_DRV|GND_LOGIC nfet L=0.7U W=10U
Mx2_XMN6_79 OUT x2_n5 GND_DRV|GND_LOGIC GND_DRV|GND_LOGIC nfet L=0.7U W=10U
Mx2_XMN6_8 OUT x2_n5 GND_DRV|GND_LOGIC GND_DRV|GND_LOGIC nfet L=0.7U W=10U
Mx2_XMN6_80 OUT x2_n5 GND_DRV|GND_LOGIC GND_DRV|GND_LOGIC nfet L=0.7U W=10U
Mx2_XMN6_81 OUT x2_n5 GND_DRV|GND_LOGIC GND_DRV|GND_LOGIC nfet L=0.7U W=10U
Mx2_XMN6_82 OUT x2_n5 GND_DRV|GND_LOGIC GND_DRV|GND_LOGIC nfet L=0.7U W=10U
Mx2_XMN6_83 OUT x2_n5 GND_DRV|GND_LOGIC GND_DRV|GND_LOGIC nfet L=0.7U W=10U
Mx2_XMN6_84 OUT x2_n5 GND_DRV|GND_LOGIC GND_DRV|GND_LOGIC nfet L=0.7U W=10U
Mx2_XMN6_85 OUT x2_n5 GND_DRV|GND_LOGIC GND_DRV|GND_LOGIC nfet L=0.7U W=10U
Mx2_XMN6_86 OUT x2_n5 GND_DRV|GND_LOGIC GND_DRV|GND_LOGIC nfet L=0.7U W=10U
Mx2_XMN6_87 OUT x2_n5 GND_DRV|GND_LOGIC GND_DRV|GND_LOGIC nfet L=0.7U W=10U
Mx2_XMN6_88 OUT x2_n5 GND_DRV|GND_LOGIC GND_DRV|GND_LOGIC nfet L=0.7U W=10U
Mx2_XMN6_89 OUT x2_n5 GND_DRV|GND_LOGIC GND_DRV|GND_LOGIC nfet L=0.7U W=10U
Mx2_XMN6_9 OUT x2_n5 GND_DRV|GND_LOGIC GND_DRV|GND_LOGIC nfet L=0.7U W=10U
Mx2_XMN6_90 OUT x2_n5 GND_DRV|GND_LOGIC GND_DRV|GND_LOGIC nfet L=0.7U W=10U
Mx2_XMN6_91 OUT x2_n5 GND_DRV|GND_LOGIC GND_DRV|GND_LOGIC nfet L=0.7U W=10U
Mx2_XMN6_92 OUT x2_n5 GND_DRV|GND_LOGIC GND_DRV|GND_LOGIC nfet L=0.7U W=10U
Mx2_XMN6_93 OUT x2_n5 GND_DRV|GND_LOGIC GND_DRV|GND_LOGIC nfet L=0.7U W=10U
Mx2_XMN6_94 OUT x2_n5 GND_DRV|GND_LOGIC GND_DRV|GND_LOGIC nfet L=0.7U W=10U
Mx2_XMN6_95 OUT x2_n5 GND_DRV|GND_LOGIC GND_DRV|GND_LOGIC nfet L=0.7U W=10U
Mx2_XMN6_96 OUT x2_n5 GND_DRV|GND_LOGIC GND_DRV|GND_LOGIC nfet L=0.7U W=10U
Mx2_XMN6_97 OUT x2_n5 GND_DRV|GND_LOGIC GND_DRV|GND_LOGIC nfet L=0.7U W=10U
Mx2_XMN6_98 OUT x2_n5 GND_DRV|GND_LOGIC GND_DRV|GND_LOGIC nfet L=0.7U W=10U
Mx2_XMN6_99 OUT x2_n5 GND_DRV|GND_LOGIC GND_DRV|GND_LOGIC nfet L=0.7U W=10U
Mx2_XMP1_0 x2_n1 IN_DRV VDD_DRV VDD_DRV pfet L=0.55U W=4.4U
Mx2_XMP2_0 x2_n2 x2_n1 VDD_DRV VDD_DRV pfet L=0.55U W=18U
Mx2_XMP3_0 x2_n3 x2_n2 VDD_DRV VDD_DRV pfet L=0.55U W=73U
Mx2_XMP4_0 x2_n4 x2_n3 VDD_DRV VDD_DRV pfet L=0.55U W=10U
Mx2_XMP4_1 x2_n4 x2_n3 VDD_DRV VDD_DRV pfet L=0.55U W=10U
Mx2_XMP4_10 x2_n4 x2_n3 VDD_DRV VDD_DRV pfet L=0.55U W=10U
Mx2_XMP4_11 x2_n4 x2_n3 VDD_DRV VDD_DRV pfet L=0.55U W=10U
Mx2_XMP4_12 x2_n4 x2_n3 VDD_DRV VDD_DRV pfet L=0.55U W=10U
Mx2_XMP4_13 x2_n4 x2_n3 VDD_DRV VDD_DRV pfet L=0.55U W=10U
Mx2_XMP4_14 x2_n4 x2_n3 VDD_DRV VDD_DRV pfet L=0.55U W=10U
Mx2_XMP4_15 x2_n4 x2_n3 VDD_DRV VDD_DRV pfet L=0.55U W=10U
Mx2_XMP4_16 x2_n4 x2_n3 VDD_DRV VDD_DRV pfet L=0.55U W=10U
Mx2_XMP4_17 x2_n4 x2_n3 VDD_DRV VDD_DRV pfet L=0.55U W=10U
Mx2_XMP4_18 x2_n4 x2_n3 VDD_DRV VDD_DRV pfet L=0.55U W=10U
Mx2_XMP4_19 x2_n4 x2_n3 VDD_DRV VDD_DRV pfet L=0.55U W=10U
Mx2_XMP4_2 x2_n4 x2_n3 VDD_DRV VDD_DRV pfet L=0.55U W=10U
Mx2_XMP4_20 x2_n4 x2_n3 VDD_DRV VDD_DRV pfet L=0.55U W=10U
Mx2_XMP4_21 x2_n4 x2_n3 VDD_DRV VDD_DRV pfet L=0.55U W=10U
Mx2_XMP4_22 x2_n4 x2_n3 VDD_DRV VDD_DRV pfet L=0.55U W=10U
Mx2_XMP4_23 x2_n4 x2_n3 VDD_DRV VDD_DRV pfet L=0.55U W=10U
Mx2_XMP4_24 x2_n4 x2_n3 VDD_DRV VDD_DRV pfet L=0.55U W=10U
Mx2_XMP4_25 x2_n4 x2_n3 VDD_DRV VDD_DRV pfet L=0.55U W=10U
Mx2_XMP4_26 x2_n4 x2_n3 VDD_DRV VDD_DRV pfet L=0.55U W=10U
Mx2_XMP4_27 x2_n4 x2_n3 VDD_DRV VDD_DRV pfet L=0.55U W=10U
Mx2_XMP4_28 x2_n4 x2_n3 VDD_DRV VDD_DRV pfet L=0.55U W=10U
Mx2_XMP4_29 x2_n4 x2_n3 VDD_DRV VDD_DRV pfet L=0.55U W=10U
Mx2_XMP4_3 x2_n4 x2_n3 VDD_DRV VDD_DRV pfet L=0.55U W=10U
Mx2_XMP4_4 x2_n4 x2_n3 VDD_DRV VDD_DRV pfet L=0.55U W=10U
Mx2_XMP4_5 x2_n4 x2_n3 VDD_DRV VDD_DRV pfet L=0.55U W=10U
Mx2_XMP4_6 x2_n4 x2_n3 VDD_DRV VDD_DRV pfet L=0.55U W=10U
Mx2_XMP4_7 x2_n4 x2_n3 VDD_DRV VDD_DRV pfet L=0.55U W=10U
Mx2_XMP4_8 x2_n4 x2_n3 VDD_DRV VDD_DRV pfet L=0.55U W=10U
Mx2_XMP4_9 x2_n4 x2_n3 VDD_DRV VDD_DRV pfet L=0.55U W=10U
Mx2_XMP5_0 x2_n5 x2_n4 VDD_DRV VDD_DRV pfet L=0.55U W=10U
Mx2_XMP5_1 x2_n5 x2_n4 VDD_DRV VDD_DRV pfet L=0.55U W=10U
Mx2_XMP5_10 x2_n5 x2_n4 VDD_DRV VDD_DRV pfet L=0.55U W=10U
Mx2_XMP5_100 x2_n5 x2_n4 VDD_DRV VDD_DRV pfet L=0.55U W=10U
Mx2_XMP5_101 x2_n5 x2_n4 VDD_DRV VDD_DRV pfet L=0.55U W=10U
Mx2_XMP5_102 x2_n5 x2_n4 VDD_DRV VDD_DRV pfet L=0.55U W=10U
Mx2_XMP5_103 x2_n5 x2_n4 VDD_DRV VDD_DRV pfet L=0.55U W=10U
Mx2_XMP5_104 x2_n5 x2_n4 VDD_DRV VDD_DRV pfet L=0.55U W=10U
Mx2_XMP5_105 x2_n5 x2_n4 VDD_DRV VDD_DRV pfet L=0.55U W=10U
Mx2_XMP5_106 x2_n5 x2_n4 VDD_DRV VDD_DRV pfet L=0.55U W=10U
Mx2_XMP5_107 x2_n5 x2_n4 VDD_DRV VDD_DRV pfet L=0.55U W=10U
Mx2_XMP5_108 x2_n5 x2_n4 VDD_DRV VDD_DRV pfet L=0.55U W=10U
Mx2_XMP5_109 x2_n5 x2_n4 VDD_DRV VDD_DRV pfet L=0.55U W=10U
Mx2_XMP5_11 x2_n5 x2_n4 VDD_DRV VDD_DRV pfet L=0.55U W=10U
Mx2_XMP5_110 x2_n5 x2_n4 VDD_DRV VDD_DRV pfet L=0.55U W=10U
Mx2_XMP5_111 x2_n5 x2_n4 VDD_DRV VDD_DRV pfet L=0.55U W=10U
Mx2_XMP5_112 x2_n5 x2_n4 VDD_DRV VDD_DRV pfet L=0.55U W=10U
Mx2_XMP5_113 x2_n5 x2_n4 VDD_DRV VDD_DRV pfet L=0.55U W=10U
Mx2_XMP5_114 x2_n5 x2_n4 VDD_DRV VDD_DRV pfet L=0.55U W=10U
Mx2_XMP5_115 x2_n5 x2_n4 VDD_DRV VDD_DRV pfet L=0.55U W=10U
Mx2_XMP5_116 x2_n5 x2_n4 VDD_DRV VDD_DRV pfet L=0.55U W=10U
Mx2_XMP5_117 x2_n5 x2_n4 VDD_DRV VDD_DRV pfet L=0.55U W=10U
Mx2_XMP5_118 x2_n5 x2_n4 VDD_DRV VDD_DRV pfet L=0.55U W=10U
Mx2_XMP5_119 x2_n5 x2_n4 VDD_DRV VDD_DRV pfet L=0.55U W=10U
Mx2_XMP5_12 x2_n5 x2_n4 VDD_DRV VDD_DRV pfet L=0.55U W=10U
Mx2_XMP5_120 x2_n5 x2_n4 VDD_DRV VDD_DRV pfet L=0.55U W=10U
Mx2_XMP5_121 x2_n5 x2_n4 VDD_DRV VDD_DRV pfet L=0.55U W=10U
Mx2_XMP5_13 x2_n5 x2_n4 VDD_DRV VDD_DRV pfet L=0.55U W=10U
Mx2_XMP5_14 x2_n5 x2_n4 VDD_DRV VDD_DRV pfet L=0.55U W=10U
Mx2_XMP5_15 x2_n5 x2_n4 VDD_DRV VDD_DRV pfet L=0.55U W=10U
Mx2_XMP5_16 x2_n5 x2_n4 VDD_DRV VDD_DRV pfet L=0.55U W=10U
Mx2_XMP5_17 x2_n5 x2_n4 VDD_DRV VDD_DRV pfet L=0.55U W=10U
Mx2_XMP5_18 x2_n5 x2_n4 VDD_DRV VDD_DRV pfet L=0.55U W=10U
Mx2_XMP5_19 x2_n5 x2_n4 VDD_DRV VDD_DRV pfet L=0.55U W=10U
Mx2_XMP5_2 x2_n5 x2_n4 VDD_DRV VDD_DRV pfet L=0.55U W=10U
Mx2_XMP5_20 x2_n5 x2_n4 VDD_DRV VDD_DRV pfet L=0.55U W=10U
Mx2_XMP5_21 x2_n5 x2_n4 VDD_DRV VDD_DRV pfet L=0.55U W=10U
Mx2_XMP5_22 x2_n5 x2_n4 VDD_DRV VDD_DRV pfet L=0.55U W=10U
Mx2_XMP5_23 x2_n5 x2_n4 VDD_DRV VDD_DRV pfet L=0.55U W=10U
Mx2_XMP5_24 x2_n5 x2_n4 VDD_DRV VDD_DRV pfet L=0.55U W=10U
Mx2_XMP5_25 x2_n5 x2_n4 VDD_DRV VDD_DRV pfet L=0.55U W=10U
Mx2_XMP5_26 x2_n5 x2_n4 VDD_DRV VDD_DRV pfet L=0.55U W=10U
Mx2_XMP5_27 x2_n5 x2_n4 VDD_DRV VDD_DRV pfet L=0.55U W=10U
Mx2_XMP5_28 x2_n5 x2_n4 VDD_DRV VDD_DRV pfet L=0.55U W=10U
Mx2_XMP5_29 x2_n5 x2_n4 VDD_DRV VDD_DRV pfet L=0.55U W=10U
Mx2_XMP5_3 x2_n5 x2_n4 VDD_DRV VDD_DRV pfet L=0.55U W=10U
Mx2_XMP5_30 x2_n5 x2_n4 VDD_DRV VDD_DRV pfet L=0.55U W=10U
Mx2_XMP5_31 x2_n5 x2_n4 VDD_DRV VDD_DRV pfet L=0.55U W=10U
Mx2_XMP5_32 x2_n5 x2_n4 VDD_DRV VDD_DRV pfet L=0.55U W=10U
Mx2_XMP5_33 x2_n5 x2_n4 VDD_DRV VDD_DRV pfet L=0.55U W=10U
Mx2_XMP5_34 x2_n5 x2_n4 VDD_DRV VDD_DRV pfet L=0.55U W=10U
Mx2_XMP5_35 x2_n5 x2_n4 VDD_DRV VDD_DRV pfet L=0.55U W=10U
Mx2_XMP5_36 x2_n5 x2_n4 VDD_DRV VDD_DRV pfet L=0.55U W=10U
Mx2_XMP5_37 x2_n5 x2_n4 VDD_DRV VDD_DRV pfet L=0.55U W=10U
Mx2_XMP5_38 x2_n5 x2_n4 VDD_DRV VDD_DRV pfet L=0.55U W=10U
Mx2_XMP5_39 x2_n5 x2_n4 VDD_DRV VDD_DRV pfet L=0.55U W=10U
Mx2_XMP5_4 x2_n5 x2_n4 VDD_DRV VDD_DRV pfet L=0.55U W=10U
Mx2_XMP5_40 x2_n5 x2_n4 VDD_DRV VDD_DRV pfet L=0.55U W=10U
Mx2_XMP5_41 x2_n5 x2_n4 VDD_DRV VDD_DRV pfet L=0.55U W=10U
Mx2_XMP5_42 x2_n5 x2_n4 VDD_DRV VDD_DRV pfet L=0.55U W=10U
Mx2_XMP5_43 x2_n5 x2_n4 VDD_DRV VDD_DRV pfet L=0.55U W=10U
Mx2_XMP5_44 x2_n5 x2_n4 VDD_DRV VDD_DRV pfet L=0.55U W=10U
Mx2_XMP5_45 x2_n5 x2_n4 VDD_DRV VDD_DRV pfet L=0.55U W=10U
Mx2_XMP5_46 x2_n5 x2_n4 VDD_DRV VDD_DRV pfet L=0.55U W=10U
Mx2_XMP5_47 x2_n5 x2_n4 VDD_DRV VDD_DRV pfet L=0.55U W=10U
Mx2_XMP5_48 x2_n5 x2_n4 VDD_DRV VDD_DRV pfet L=0.55U W=10U
Mx2_XMP5_49 x2_n5 x2_n4 VDD_DRV VDD_DRV pfet L=0.55U W=10U
Mx2_XMP5_5 x2_n5 x2_n4 VDD_DRV VDD_DRV pfet L=0.55U W=10U
Mx2_XMP5_50 x2_n5 x2_n4 VDD_DRV VDD_DRV pfet L=0.55U W=10U
Mx2_XMP5_51 x2_n5 x2_n4 VDD_DRV VDD_DRV pfet L=0.55U W=10U
Mx2_XMP5_52 x2_n5 x2_n4 VDD_DRV VDD_DRV pfet L=0.55U W=10U
Mx2_XMP5_53 x2_n5 x2_n4 VDD_DRV VDD_DRV pfet L=0.55U W=10U
Mx2_XMP5_54 x2_n5 x2_n4 VDD_DRV VDD_DRV pfet L=0.55U W=10U
Mx2_XMP5_55 x2_n5 x2_n4 VDD_DRV VDD_DRV pfet L=0.55U W=10U
Mx2_XMP5_56 x2_n5 x2_n4 VDD_DRV VDD_DRV pfet L=0.55U W=10U
Mx2_XMP5_57 x2_n5 x2_n4 VDD_DRV VDD_DRV pfet L=0.55U W=10U
Mx2_XMP5_58 x2_n5 x2_n4 VDD_DRV VDD_DRV pfet L=0.55U W=10U
Mx2_XMP5_59 x2_n5 x2_n4 VDD_DRV VDD_DRV pfet L=0.55U W=10U
Mx2_XMP5_6 x2_n5 x2_n4 VDD_DRV VDD_DRV pfet L=0.55U W=10U
Mx2_XMP5_60 x2_n5 x2_n4 VDD_DRV VDD_DRV pfet L=0.55U W=10U
Mx2_XMP5_61 x2_n5 x2_n4 VDD_DRV VDD_DRV pfet L=0.55U W=10U
Mx2_XMP5_62 x2_n5 x2_n4 VDD_DRV VDD_DRV pfet L=0.55U W=10U
Mx2_XMP5_63 x2_n5 x2_n4 VDD_DRV VDD_DRV pfet L=0.55U W=10U
Mx2_XMP5_64 x2_n5 x2_n4 VDD_DRV VDD_DRV pfet L=0.55U W=10U
Mx2_XMP5_65 x2_n5 x2_n4 VDD_DRV VDD_DRV pfet L=0.55U W=10U
Mx2_XMP5_66 x2_n5 x2_n4 VDD_DRV VDD_DRV pfet L=0.55U W=10U
Mx2_XMP5_67 x2_n5 x2_n4 VDD_DRV VDD_DRV pfet L=0.55U W=10U
Mx2_XMP5_68 x2_n5 x2_n4 VDD_DRV VDD_DRV pfet L=0.55U W=10U
Mx2_XMP5_69 x2_n5 x2_n4 VDD_DRV VDD_DRV pfet L=0.55U W=10U
Mx2_XMP5_7 x2_n5 x2_n4 VDD_DRV VDD_DRV pfet L=0.55U W=10U
Mx2_XMP5_70 x2_n5 x2_n4 VDD_DRV VDD_DRV pfet L=0.55U W=10U
Mx2_XMP5_71 x2_n5 x2_n4 VDD_DRV VDD_DRV pfet L=0.55U W=10U
Mx2_XMP5_72 x2_n5 x2_n4 VDD_DRV VDD_DRV pfet L=0.55U W=10U
Mx2_XMP5_73 x2_n5 x2_n4 VDD_DRV VDD_DRV pfet L=0.55U W=10U
Mx2_XMP5_74 x2_n5 x2_n4 VDD_DRV VDD_DRV pfet L=0.55U W=10U
Mx2_XMP5_75 x2_n5 x2_n4 VDD_DRV VDD_DRV pfet L=0.55U W=10U
Mx2_XMP5_76 x2_n5 x2_n4 VDD_DRV VDD_DRV pfet L=0.55U W=10U
Mx2_XMP5_77 x2_n5 x2_n4 VDD_DRV VDD_DRV pfet L=0.55U W=10U
Mx2_XMP5_78 x2_n5 x2_n4 VDD_DRV VDD_DRV pfet L=0.55U W=10U
Mx2_XMP5_79 x2_n5 x2_n4 VDD_DRV VDD_DRV pfet L=0.55U W=10U
Mx2_XMP5_8 x2_n5 x2_n4 VDD_DRV VDD_DRV pfet L=0.55U W=10U
Mx2_XMP5_80 x2_n5 x2_n4 VDD_DRV VDD_DRV pfet L=0.55U W=10U
Mx2_XMP5_81 x2_n5 x2_n4 VDD_DRV VDD_DRV pfet L=0.55U W=10U
Mx2_XMP5_82 x2_n5 x2_n4 VDD_DRV VDD_DRV pfet L=0.55U W=10U
Mx2_XMP5_83 x2_n5 x2_n4 VDD_DRV VDD_DRV pfet L=0.55U W=10U
Mx2_XMP5_84 x2_n5 x2_n4 VDD_DRV VDD_DRV pfet L=0.55U W=10U
Mx2_XMP5_85 x2_n5 x2_n4 VDD_DRV VDD_DRV pfet L=0.55U W=10U
Mx2_XMP5_86 x2_n5 x2_n4 VDD_DRV VDD_DRV pfet L=0.55U W=10U
Mx2_XMP5_87 x2_n5 x2_n4 VDD_DRV VDD_DRV pfet L=0.55U W=10U
Mx2_XMP5_88 x2_n5 x2_n4 VDD_DRV VDD_DRV pfet L=0.55U W=10U
Mx2_XMP5_89 x2_n5 x2_n4 VDD_DRV VDD_DRV pfet L=0.55U W=10U
Mx2_XMP5_9 x2_n5 x2_n4 VDD_DRV VDD_DRV pfet L=0.55U W=10U
Mx2_XMP5_90 x2_n5 x2_n4 VDD_DRV VDD_DRV pfet L=0.55U W=10U
Mx2_XMP5_91 x2_n5 x2_n4 VDD_DRV VDD_DRV pfet L=0.55U W=10U
Mx2_XMP5_92 x2_n5 x2_n4 VDD_DRV VDD_DRV pfet L=0.55U W=10U
Mx2_XMP5_93 x2_n5 x2_n4 VDD_DRV VDD_DRV pfet L=0.55U W=10U
Mx2_XMP5_94 x2_n5 x2_n4 VDD_DRV VDD_DRV pfet L=0.55U W=10U
Mx2_XMP5_95 x2_n5 x2_n4 VDD_DRV VDD_DRV pfet L=0.55U W=10U
Mx2_XMP5_96 x2_n5 x2_n4 VDD_DRV VDD_DRV pfet L=0.55U W=10U
Mx2_XMP5_97 x2_n5 x2_n4 VDD_DRV VDD_DRV pfet L=0.55U W=10U
Mx2_XMP5_98 x2_n5 x2_n4 VDD_DRV VDD_DRV pfet L=0.55U W=10U
Mx2_XMP5_99 x2_n5 x2_n4 VDD_DRV VDD_DRV pfet L=0.55U W=10U
Mx2_XMP6_0 OUT x2_n5 VDD_DRV VDD_DRV pfet L=0.55U W=10U
Mx2_XMP6_1 OUT x2_n5 VDD_DRV VDD_DRV pfet L=0.55U W=10U
Mx2_XMP6_10 OUT x2_n5 VDD_DRV VDD_DRV pfet L=0.55U W=10U
Mx2_XMP6_100 OUT x2_n5 VDD_DRV VDD_DRV pfet L=0.55U W=10U
Mx2_XMP6_101 OUT x2_n5 VDD_DRV VDD_DRV pfet L=0.55U W=10U
Mx2_XMP6_102 OUT x2_n5 VDD_DRV VDD_DRV pfet L=0.55U W=10U
Mx2_XMP6_103 OUT x2_n5 VDD_DRV VDD_DRV pfet L=0.55U W=10U
Mx2_XMP6_104 OUT x2_n5 VDD_DRV VDD_DRV pfet L=0.55U W=10U
Mx2_XMP6_105 OUT x2_n5 VDD_DRV VDD_DRV pfet L=0.55U W=10U
Mx2_XMP6_106 OUT x2_n5 VDD_DRV VDD_DRV pfet L=0.55U W=10U
Mx2_XMP6_107 OUT x2_n5 VDD_DRV VDD_DRV pfet L=0.55U W=10U
Mx2_XMP6_108 OUT x2_n5 VDD_DRV VDD_DRV pfet L=0.55U W=10U
Mx2_XMP6_109 OUT x2_n5 VDD_DRV VDD_DRV pfet L=0.55U W=10U
Mx2_XMP6_11 OUT x2_n5 VDD_DRV VDD_DRV pfet L=0.55U W=10U
Mx2_XMP6_110 OUT x2_n5 VDD_DRV VDD_DRV pfet L=0.55U W=10U
Mx2_XMP6_111 OUT x2_n5 VDD_DRV VDD_DRV pfet L=0.55U W=10U
Mx2_XMP6_112 OUT x2_n5 VDD_DRV VDD_DRV pfet L=0.55U W=10U
Mx2_XMP6_113 OUT x2_n5 VDD_DRV VDD_DRV pfet L=0.55U W=10U
Mx2_XMP6_114 OUT x2_n5 VDD_DRV VDD_DRV pfet L=0.55U W=10U
Mx2_XMP6_115 OUT x2_n5 VDD_DRV VDD_DRV pfet L=0.55U W=10U
Mx2_XMP6_116 OUT x2_n5 VDD_DRV VDD_DRV pfet L=0.55U W=10U
Mx2_XMP6_117 OUT x2_n5 VDD_DRV VDD_DRV pfet L=0.55U W=10U
Mx2_XMP6_118 OUT x2_n5 VDD_DRV VDD_DRV pfet L=0.55U W=10U
Mx2_XMP6_119 OUT x2_n5 VDD_DRV VDD_DRV pfet L=0.55U W=10U
Mx2_XMP6_12 OUT x2_n5 VDD_DRV VDD_DRV pfet L=0.55U W=10U
Mx2_XMP6_120 OUT x2_n5 VDD_DRV VDD_DRV pfet L=0.55U W=10U
Mx2_XMP6_121 OUT x2_n5 VDD_DRV VDD_DRV pfet L=0.55U W=10U
Mx2_XMP6_122 OUT x2_n5 VDD_DRV VDD_DRV pfet L=0.55U W=10U
Mx2_XMP6_123 OUT x2_n5 VDD_DRV VDD_DRV pfet L=0.55U W=10U
Mx2_XMP6_124 OUT x2_n5 VDD_DRV VDD_DRV pfet L=0.55U W=10U
Mx2_XMP6_125 OUT x2_n5 VDD_DRV VDD_DRV pfet L=0.55U W=10U
Mx2_XMP6_126 OUT x2_n5 VDD_DRV VDD_DRV pfet L=0.55U W=10U
Mx2_XMP6_127 OUT x2_n5 VDD_DRV VDD_DRV pfet L=0.55U W=10U
Mx2_XMP6_128 OUT x2_n5 VDD_DRV VDD_DRV pfet L=0.55U W=10U
Mx2_XMP6_129 OUT x2_n5 VDD_DRV VDD_DRV pfet L=0.55U W=10U
Mx2_XMP6_13 OUT x2_n5 VDD_DRV VDD_DRV pfet L=0.55U W=10U
Mx2_XMP6_130 OUT x2_n5 VDD_DRV VDD_DRV pfet L=0.55U W=10U
Mx2_XMP6_131 OUT x2_n5 VDD_DRV VDD_DRV pfet L=0.55U W=10U
Mx2_XMP6_132 OUT x2_n5 VDD_DRV VDD_DRV pfet L=0.55U W=10U
Mx2_XMP6_133 OUT x2_n5 VDD_DRV VDD_DRV pfet L=0.55U W=10U
Mx2_XMP6_134 OUT x2_n5 VDD_DRV VDD_DRV pfet L=0.55U W=10U
Mx2_XMP6_135 OUT x2_n5 VDD_DRV VDD_DRV pfet L=0.55U W=10U
Mx2_XMP6_136 OUT x2_n5 VDD_DRV VDD_DRV pfet L=0.55U W=10U
Mx2_XMP6_137 OUT x2_n5 VDD_DRV VDD_DRV pfet L=0.55U W=10U
Mx2_XMP6_138 OUT x2_n5 VDD_DRV VDD_DRV pfet L=0.55U W=10U
Mx2_XMP6_139 OUT x2_n5 VDD_DRV VDD_DRV pfet L=0.55U W=10U
Mx2_XMP6_14 OUT x2_n5 VDD_DRV VDD_DRV pfet L=0.55U W=10U
Mx2_XMP6_140 OUT x2_n5 VDD_DRV VDD_DRV pfet L=0.55U W=10U
Mx2_XMP6_141 OUT x2_n5 VDD_DRV VDD_DRV pfet L=0.55U W=10U
Mx2_XMP6_142 OUT x2_n5 VDD_DRV VDD_DRV pfet L=0.55U W=10U
Mx2_XMP6_143 OUT x2_n5 VDD_DRV VDD_DRV pfet L=0.55U W=10U
Mx2_XMP6_144 OUT x2_n5 VDD_DRV VDD_DRV pfet L=0.55U W=10U
Mx2_XMP6_145 OUT x2_n5 VDD_DRV VDD_DRV pfet L=0.55U W=10U
Mx2_XMP6_146 OUT x2_n5 VDD_DRV VDD_DRV pfet L=0.55U W=10U
Mx2_XMP6_147 OUT x2_n5 VDD_DRV VDD_DRV pfet L=0.55U W=10U
Mx2_XMP6_148 OUT x2_n5 VDD_DRV VDD_DRV pfet L=0.55U W=10U
Mx2_XMP6_149 OUT x2_n5 VDD_DRV VDD_DRV pfet L=0.55U W=10U
Mx2_XMP6_15 OUT x2_n5 VDD_DRV VDD_DRV pfet L=0.55U W=10U
Mx2_XMP6_150 OUT x2_n5 VDD_DRV VDD_DRV pfet L=0.55U W=10U
Mx2_XMP6_151 OUT x2_n5 VDD_DRV VDD_DRV pfet L=0.55U W=10U
Mx2_XMP6_152 OUT x2_n5 VDD_DRV VDD_DRV pfet L=0.55U W=10U
Mx2_XMP6_153 OUT x2_n5 VDD_DRV VDD_DRV pfet L=0.55U W=10U
Mx2_XMP6_154 OUT x2_n5 VDD_DRV VDD_DRV pfet L=0.55U W=10U
Mx2_XMP6_155 OUT x2_n5 VDD_DRV VDD_DRV pfet L=0.55U W=10U
Mx2_XMP6_156 OUT x2_n5 VDD_DRV VDD_DRV pfet L=0.55U W=10U
Mx2_XMP6_157 OUT x2_n5 VDD_DRV VDD_DRV pfet L=0.55U W=10U
Mx2_XMP6_158 OUT x2_n5 VDD_DRV VDD_DRV pfet L=0.55U W=10U
Mx2_XMP6_159 OUT x2_n5 VDD_DRV VDD_DRV pfet L=0.55U W=10U
Mx2_XMP6_16 OUT x2_n5 VDD_DRV VDD_DRV pfet L=0.55U W=10U
Mx2_XMP6_160 OUT x2_n5 VDD_DRV VDD_DRV pfet L=0.55U W=10U
Mx2_XMP6_161 OUT x2_n5 VDD_DRV VDD_DRV pfet L=0.55U W=10U
Mx2_XMP6_162 OUT x2_n5 VDD_DRV VDD_DRV pfet L=0.55U W=10U
Mx2_XMP6_163 OUT x2_n5 VDD_DRV VDD_DRV pfet L=0.55U W=10U
Mx2_XMP6_164 OUT x2_n5 VDD_DRV VDD_DRV pfet L=0.55U W=10U
Mx2_XMP6_165 OUT x2_n5 VDD_DRV VDD_DRV pfet L=0.55U W=10U
Mx2_XMP6_166 OUT x2_n5 VDD_DRV VDD_DRV pfet L=0.55U W=10U
Mx2_XMP6_167 OUT x2_n5 VDD_DRV VDD_DRV pfet L=0.55U W=10U
Mx2_XMP6_168 OUT x2_n5 VDD_DRV VDD_DRV pfet L=0.55U W=10U
Mx2_XMP6_169 OUT x2_n5 VDD_DRV VDD_DRV pfet L=0.55U W=10U
Mx2_XMP6_17 OUT x2_n5 VDD_DRV VDD_DRV pfet L=0.55U W=10U
Mx2_XMP6_170 OUT x2_n5 VDD_DRV VDD_DRV pfet L=0.55U W=10U
Mx2_XMP6_171 OUT x2_n5 VDD_DRV VDD_DRV pfet L=0.55U W=10U
Mx2_XMP6_172 OUT x2_n5 VDD_DRV VDD_DRV pfet L=0.55U W=10U
Mx2_XMP6_173 OUT x2_n5 VDD_DRV VDD_DRV pfet L=0.55U W=10U
Mx2_XMP6_174 OUT x2_n5 VDD_DRV VDD_DRV pfet L=0.55U W=10U
Mx2_XMP6_175 OUT x2_n5 VDD_DRV VDD_DRV pfet L=0.55U W=10U
Mx2_XMP6_176 OUT x2_n5 VDD_DRV VDD_DRV pfet L=0.55U W=10U
Mx2_XMP6_177 OUT x2_n5 VDD_DRV VDD_DRV pfet L=0.55U W=10U
Mx2_XMP6_178 OUT x2_n5 VDD_DRV VDD_DRV pfet L=0.55U W=10U
Mx2_XMP6_179 OUT x2_n5 VDD_DRV VDD_DRV pfet L=0.55U W=10U
Mx2_XMP6_18 OUT x2_n5 VDD_DRV VDD_DRV pfet L=0.55U W=10U
Mx2_XMP6_180 OUT x2_n5 VDD_DRV VDD_DRV pfet L=0.55U W=10U
Mx2_XMP6_181 OUT x2_n5 VDD_DRV VDD_DRV pfet L=0.55U W=10U
Mx2_XMP6_182 OUT x2_n5 VDD_DRV VDD_DRV pfet L=0.55U W=10U
Mx2_XMP6_183 OUT x2_n5 VDD_DRV VDD_DRV pfet L=0.55U W=10U
Mx2_XMP6_184 OUT x2_n5 VDD_DRV VDD_DRV pfet L=0.55U W=10U
Mx2_XMP6_185 OUT x2_n5 VDD_DRV VDD_DRV pfet L=0.55U W=10U
Mx2_XMP6_186 OUT x2_n5 VDD_DRV VDD_DRV pfet L=0.55U W=10U
Mx2_XMP6_187 OUT x2_n5 VDD_DRV VDD_DRV pfet L=0.55U W=10U
Mx2_XMP6_188 OUT x2_n5 VDD_DRV VDD_DRV pfet L=0.55U W=10U
Mx2_XMP6_189 OUT x2_n5 VDD_DRV VDD_DRV pfet L=0.55U W=10U
Mx2_XMP6_19 OUT x2_n5 VDD_DRV VDD_DRV pfet L=0.55U W=10U
Mx2_XMP6_190 OUT x2_n5 VDD_DRV VDD_DRV pfet L=0.55U W=10U
Mx2_XMP6_191 OUT x2_n5 VDD_DRV VDD_DRV pfet L=0.55U W=10U
Mx2_XMP6_192 OUT x2_n5 VDD_DRV VDD_DRV pfet L=0.55U W=10U
Mx2_XMP6_193 OUT x2_n5 VDD_DRV VDD_DRV pfet L=0.55U W=10U
Mx2_XMP6_194 OUT x2_n5 VDD_DRV VDD_DRV pfet L=0.55U W=10U
Mx2_XMP6_195 OUT x2_n5 VDD_DRV VDD_DRV pfet L=0.55U W=10U
Mx2_XMP6_196 OUT x2_n5 VDD_DRV VDD_DRV pfet L=0.55U W=10U
Mx2_XMP6_197 OUT x2_n5 VDD_DRV VDD_DRV pfet L=0.55U W=10U
Mx2_XMP6_198 OUT x2_n5 VDD_DRV VDD_DRV pfet L=0.55U W=10U
Mx2_XMP6_199 OUT x2_n5 VDD_DRV VDD_DRV pfet L=0.55U W=10U
Mx2_XMP6_2 OUT x2_n5 VDD_DRV VDD_DRV pfet L=0.55U W=10U
Mx2_XMP6_20 OUT x2_n5 VDD_DRV VDD_DRV pfet L=0.55U W=10U
Mx2_XMP6_200 OUT x2_n5 VDD_DRV VDD_DRV pfet L=0.55U W=10U
Mx2_XMP6_201 OUT x2_n5 VDD_DRV VDD_DRV pfet L=0.55U W=10U
Mx2_XMP6_202 OUT x2_n5 VDD_DRV VDD_DRV pfet L=0.55U W=10U
Mx2_XMP6_203 OUT x2_n5 VDD_DRV VDD_DRV pfet L=0.55U W=10U
Mx2_XMP6_204 OUT x2_n5 VDD_DRV VDD_DRV pfet L=0.55U W=10U
Mx2_XMP6_205 OUT x2_n5 VDD_DRV VDD_DRV pfet L=0.55U W=10U
Mx2_XMP6_206 OUT x2_n5 VDD_DRV VDD_DRV pfet L=0.55U W=10U
Mx2_XMP6_207 OUT x2_n5 VDD_DRV VDD_DRV pfet L=0.55U W=10U
Mx2_XMP6_208 OUT x2_n5 VDD_DRV VDD_DRV pfet L=0.55U W=10U
Mx2_XMP6_209 OUT x2_n5 VDD_DRV VDD_DRV pfet L=0.55U W=10U
Mx2_XMP6_21 OUT x2_n5 VDD_DRV VDD_DRV pfet L=0.55U W=10U
Mx2_XMP6_210 OUT x2_n5 VDD_DRV VDD_DRV pfet L=0.55U W=10U
Mx2_XMP6_211 OUT x2_n5 VDD_DRV VDD_DRV pfet L=0.55U W=10U
Mx2_XMP6_212 OUT x2_n5 VDD_DRV VDD_DRV pfet L=0.55U W=10U
Mx2_XMP6_213 OUT x2_n5 VDD_DRV VDD_DRV pfet L=0.55U W=10U
Mx2_XMP6_214 OUT x2_n5 VDD_DRV VDD_DRV pfet L=0.55U W=10U
Mx2_XMP6_215 OUT x2_n5 VDD_DRV VDD_DRV pfet L=0.55U W=10U
Mx2_XMP6_216 OUT x2_n5 VDD_DRV VDD_DRV pfet L=0.55U W=10U
Mx2_XMP6_217 OUT x2_n5 VDD_DRV VDD_DRV pfet L=0.55U W=10U
Mx2_XMP6_218 OUT x2_n5 VDD_DRV VDD_DRV pfet L=0.55U W=10U
Mx2_XMP6_219 OUT x2_n5 VDD_DRV VDD_DRV pfet L=0.55U W=10U
Mx2_XMP6_22 OUT x2_n5 VDD_DRV VDD_DRV pfet L=0.55U W=10U
Mx2_XMP6_220 OUT x2_n5 VDD_DRV VDD_DRV pfet L=0.55U W=10U
Mx2_XMP6_221 OUT x2_n5 VDD_DRV VDD_DRV pfet L=0.55U W=10U
Mx2_XMP6_222 OUT x2_n5 VDD_DRV VDD_DRV pfet L=0.55U W=10U
Mx2_XMP6_223 OUT x2_n5 VDD_DRV VDD_DRV pfet L=0.55U W=10U
Mx2_XMP6_224 OUT x2_n5 VDD_DRV VDD_DRV pfet L=0.55U W=10U
Mx2_XMP6_225 OUT x2_n5 VDD_DRV VDD_DRV pfet L=0.55U W=10U
Mx2_XMP6_226 OUT x2_n5 VDD_DRV VDD_DRV pfet L=0.55U W=10U
Mx2_XMP6_227 OUT x2_n5 VDD_DRV VDD_DRV pfet L=0.55U W=10U
Mx2_XMP6_228 OUT x2_n5 VDD_DRV VDD_DRV pfet L=0.55U W=10U
Mx2_XMP6_229 OUT x2_n5 VDD_DRV VDD_DRV pfet L=0.55U W=10U
Mx2_XMP6_23 OUT x2_n5 VDD_DRV VDD_DRV pfet L=0.55U W=10U
Mx2_XMP6_230 OUT x2_n5 VDD_DRV VDD_DRV pfet L=0.55U W=10U
Mx2_XMP6_231 OUT x2_n5 VDD_DRV VDD_DRV pfet L=0.55U W=10U
Mx2_XMP6_232 OUT x2_n5 VDD_DRV VDD_DRV pfet L=0.55U W=10U
Mx2_XMP6_233 OUT x2_n5 VDD_DRV VDD_DRV pfet L=0.55U W=10U
Mx2_XMP6_234 OUT x2_n5 VDD_DRV VDD_DRV pfet L=0.55U W=10U
Mx2_XMP6_235 OUT x2_n5 VDD_DRV VDD_DRV pfet L=0.55U W=10U
Mx2_XMP6_236 OUT x2_n5 VDD_DRV VDD_DRV pfet L=0.55U W=10U
Mx2_XMP6_237 OUT x2_n5 VDD_DRV VDD_DRV pfet L=0.55U W=10U
Mx2_XMP6_238 OUT x2_n5 VDD_DRV VDD_DRV pfet L=0.55U W=10U
Mx2_XMP6_239 OUT x2_n5 VDD_DRV VDD_DRV pfet L=0.55U W=10U
Mx2_XMP6_24 OUT x2_n5 VDD_DRV VDD_DRV pfet L=0.55U W=10U
Mx2_XMP6_240 OUT x2_n5 VDD_DRV VDD_DRV pfet L=0.55U W=10U
Mx2_XMP6_241 OUT x2_n5 VDD_DRV VDD_DRV pfet L=0.55U W=10U
Mx2_XMP6_242 OUT x2_n5 VDD_DRV VDD_DRV pfet L=0.55U W=10U
Mx2_XMP6_243 OUT x2_n5 VDD_DRV VDD_DRV pfet L=0.55U W=10U
Mx2_XMP6_244 OUT x2_n5 VDD_DRV VDD_DRV pfet L=0.55U W=10U
Mx2_XMP6_245 OUT x2_n5 VDD_DRV VDD_DRV pfet L=0.55U W=10U
Mx2_XMP6_246 OUT x2_n5 VDD_DRV VDD_DRV pfet L=0.55U W=10U
Mx2_XMP6_247 OUT x2_n5 VDD_DRV VDD_DRV pfet L=0.55U W=10U
Mx2_XMP6_248 OUT x2_n5 VDD_DRV VDD_DRV pfet L=0.55U W=10U
Mx2_XMP6_249 OUT x2_n5 VDD_DRV VDD_DRV pfet L=0.55U W=10U
Mx2_XMP6_25 OUT x2_n5 VDD_DRV VDD_DRV pfet L=0.55U W=10U
Mx2_XMP6_250 OUT x2_n5 VDD_DRV VDD_DRV pfet L=0.55U W=10U
Mx2_XMP6_251 OUT x2_n5 VDD_DRV VDD_DRV pfet L=0.55U W=10U
Mx2_XMP6_252 OUT x2_n5 VDD_DRV VDD_DRV pfet L=0.55U W=10U
Mx2_XMP6_253 OUT x2_n5 VDD_DRV VDD_DRV pfet L=0.55U W=10U
Mx2_XMP6_254 OUT x2_n5 VDD_DRV VDD_DRV pfet L=0.55U W=10U
Mx2_XMP6_255 OUT x2_n5 VDD_DRV VDD_DRV pfet L=0.55U W=10U
Mx2_XMP6_256 OUT x2_n5 VDD_DRV VDD_DRV pfet L=0.55U W=10U
Mx2_XMP6_257 OUT x2_n5 VDD_DRV VDD_DRV pfet L=0.55U W=10U
Mx2_XMP6_258 OUT x2_n5 VDD_DRV VDD_DRV pfet L=0.55U W=10U
Mx2_XMP6_259 OUT x2_n5 VDD_DRV VDD_DRV pfet L=0.55U W=10U
Mx2_XMP6_26 OUT x2_n5 VDD_DRV VDD_DRV pfet L=0.55U W=10U
Mx2_XMP6_260 OUT x2_n5 VDD_DRV VDD_DRV pfet L=0.55U W=10U
Mx2_XMP6_261 OUT x2_n5 VDD_DRV VDD_DRV pfet L=0.55U W=10U
Mx2_XMP6_262 OUT x2_n5 VDD_DRV VDD_DRV pfet L=0.55U W=10U
Mx2_XMP6_263 OUT x2_n5 VDD_DRV VDD_DRV pfet L=0.55U W=10U
Mx2_XMP6_264 OUT x2_n5 VDD_DRV VDD_DRV pfet L=0.55U W=10U
Mx2_XMP6_265 OUT x2_n5 VDD_DRV VDD_DRV pfet L=0.55U W=10U
Mx2_XMP6_266 OUT x2_n5 VDD_DRV VDD_DRV pfet L=0.55U W=10U
Mx2_XMP6_267 OUT x2_n5 VDD_DRV VDD_DRV pfet L=0.55U W=10U
Mx2_XMP6_268 OUT x2_n5 VDD_DRV VDD_DRV pfet L=0.55U W=10U
Mx2_XMP6_269 OUT x2_n5 VDD_DRV VDD_DRV pfet L=0.55U W=10U
Mx2_XMP6_27 OUT x2_n5 VDD_DRV VDD_DRV pfet L=0.55U W=10U
Mx2_XMP6_270 OUT x2_n5 VDD_DRV VDD_DRV pfet L=0.55U W=10U
Mx2_XMP6_271 OUT x2_n5 VDD_DRV VDD_DRV pfet L=0.55U W=10U
Mx2_XMP6_272 OUT x2_n5 VDD_DRV VDD_DRV pfet L=0.55U W=10U
Mx2_XMP6_273 OUT x2_n5 VDD_DRV VDD_DRV pfet L=0.55U W=10U
Mx2_XMP6_274 OUT x2_n5 VDD_DRV VDD_DRV pfet L=0.55U W=10U
Mx2_XMP6_275 OUT x2_n5 VDD_DRV VDD_DRV pfet L=0.55U W=10U
Mx2_XMP6_276 OUT x2_n5 VDD_DRV VDD_DRV pfet L=0.55U W=10U
Mx2_XMP6_277 OUT x2_n5 VDD_DRV VDD_DRV pfet L=0.55U W=10U
Mx2_XMP6_278 OUT x2_n5 VDD_DRV VDD_DRV pfet L=0.55U W=10U
Mx2_XMP6_279 OUT x2_n5 VDD_DRV VDD_DRV pfet L=0.55U W=10U
Mx2_XMP6_28 OUT x2_n5 VDD_DRV VDD_DRV pfet L=0.55U W=10U
Mx2_XMP6_280 OUT x2_n5 VDD_DRV VDD_DRV pfet L=0.55U W=10U
Mx2_XMP6_281 OUT x2_n5 VDD_DRV VDD_DRV pfet L=0.55U W=10U
Mx2_XMP6_282 OUT x2_n5 VDD_DRV VDD_DRV pfet L=0.55U W=10U
Mx2_XMP6_283 OUT x2_n5 VDD_DRV VDD_DRV pfet L=0.55U W=10U
Mx2_XMP6_284 OUT x2_n5 VDD_DRV VDD_DRV pfet L=0.55U W=10U
Mx2_XMP6_285 OUT x2_n5 VDD_DRV VDD_DRV pfet L=0.55U W=10U
Mx2_XMP6_286 OUT x2_n5 VDD_DRV VDD_DRV pfet L=0.55U W=10U
Mx2_XMP6_287 OUT x2_n5 VDD_DRV VDD_DRV pfet L=0.55U W=10U
Mx2_XMP6_288 OUT x2_n5 VDD_DRV VDD_DRV pfet L=0.55U W=10U
Mx2_XMP6_289 OUT x2_n5 VDD_DRV VDD_DRV pfet L=0.55U W=10U
Mx2_XMP6_29 OUT x2_n5 VDD_DRV VDD_DRV pfet L=0.55U W=10U
Mx2_XMP6_290 OUT x2_n5 VDD_DRV VDD_DRV pfet L=0.55U W=10U
Mx2_XMP6_291 OUT x2_n5 VDD_DRV VDD_DRV pfet L=0.55U W=10U
Mx2_XMP6_292 OUT x2_n5 VDD_DRV VDD_DRV pfet L=0.55U W=10U
Mx2_XMP6_293 OUT x2_n5 VDD_DRV VDD_DRV pfet L=0.55U W=10U
Mx2_XMP6_294 OUT x2_n5 VDD_DRV VDD_DRV pfet L=0.55U W=10U
Mx2_XMP6_295 OUT x2_n5 VDD_DRV VDD_DRV pfet L=0.55U W=10U
Mx2_XMP6_296 OUT x2_n5 VDD_DRV VDD_DRV pfet L=0.55U W=10U
Mx2_XMP6_297 OUT x2_n5 VDD_DRV VDD_DRV pfet L=0.55U W=10U
Mx2_XMP6_298 OUT x2_n5 VDD_DRV VDD_DRV pfet L=0.55U W=10U
Mx2_XMP6_299 OUT x2_n5 VDD_DRV VDD_DRV pfet L=0.55U W=10U
Mx2_XMP6_3 OUT x2_n5 VDD_DRV VDD_DRV pfet L=0.55U W=10U
Mx2_XMP6_30 OUT x2_n5 VDD_DRV VDD_DRV pfet L=0.55U W=10U
Mx2_XMP6_300 OUT x2_n5 VDD_DRV VDD_DRV pfet L=0.55U W=10U
Mx2_XMP6_301 OUT x2_n5 VDD_DRV VDD_DRV pfet L=0.55U W=10U
Mx2_XMP6_302 OUT x2_n5 VDD_DRV VDD_DRV pfet L=0.55U W=10U
Mx2_XMP6_303 OUT x2_n5 VDD_DRV VDD_DRV pfet L=0.55U W=10U
Mx2_XMP6_304 OUT x2_n5 VDD_DRV VDD_DRV pfet L=0.55U W=10U
Mx2_XMP6_305 OUT x2_n5 VDD_DRV VDD_DRV pfet L=0.55U W=10U
Mx2_XMP6_306 OUT x2_n5 VDD_DRV VDD_DRV pfet L=0.55U W=10U
Mx2_XMP6_307 OUT x2_n5 VDD_DRV VDD_DRV pfet L=0.55U W=10U
Mx2_XMP6_308 OUT x2_n5 VDD_DRV VDD_DRV pfet L=0.55U W=10U
Mx2_XMP6_309 OUT x2_n5 VDD_DRV VDD_DRV pfet L=0.55U W=10U
Mx2_XMP6_31 OUT x2_n5 VDD_DRV VDD_DRV pfet L=0.55U W=10U
Mx2_XMP6_310 OUT x2_n5 VDD_DRV VDD_DRV pfet L=0.55U W=10U
Mx2_XMP6_311 OUT x2_n5 VDD_DRV VDD_DRV pfet L=0.55U W=10U
Mx2_XMP6_312 OUT x2_n5 VDD_DRV VDD_DRV pfet L=0.55U W=10U
Mx2_XMP6_313 OUT x2_n5 VDD_DRV VDD_DRV pfet L=0.55U W=10U
Mx2_XMP6_314 OUT x2_n5 VDD_DRV VDD_DRV pfet L=0.55U W=10U
Mx2_XMP6_315 OUT x2_n5 VDD_DRV VDD_DRV pfet L=0.55U W=10U
Mx2_XMP6_316 OUT x2_n5 VDD_DRV VDD_DRV pfet L=0.55U W=10U
Mx2_XMP6_317 OUT x2_n5 VDD_DRV VDD_DRV pfet L=0.55U W=10U
Mx2_XMP6_318 OUT x2_n5 VDD_DRV VDD_DRV pfet L=0.55U W=10U
Mx2_XMP6_319 OUT x2_n5 VDD_DRV VDD_DRV pfet L=0.55U W=10U
Mx2_XMP6_32 OUT x2_n5 VDD_DRV VDD_DRV pfet L=0.55U W=10U
Mx2_XMP6_320 OUT x2_n5 VDD_DRV VDD_DRV pfet L=0.55U W=10U
Mx2_XMP6_321 OUT x2_n5 VDD_DRV VDD_DRV pfet L=0.55U W=10U
Mx2_XMP6_322 OUT x2_n5 VDD_DRV VDD_DRV pfet L=0.55U W=10U
Mx2_XMP6_323 OUT x2_n5 VDD_DRV VDD_DRV pfet L=0.55U W=10U
Mx2_XMP6_324 OUT x2_n5 VDD_DRV VDD_DRV pfet L=0.55U W=10U
Mx2_XMP6_325 OUT x2_n5 VDD_DRV VDD_DRV pfet L=0.55U W=10U
Mx2_XMP6_326 OUT x2_n5 VDD_DRV VDD_DRV pfet L=0.55U W=10U
Mx2_XMP6_327 OUT x2_n5 VDD_DRV VDD_DRV pfet L=0.55U W=10U
Mx2_XMP6_328 OUT x2_n5 VDD_DRV VDD_DRV pfet L=0.55U W=10U
Mx2_XMP6_329 OUT x2_n5 VDD_DRV VDD_DRV pfet L=0.55U W=10U
Mx2_XMP6_33 OUT x2_n5 VDD_DRV VDD_DRV pfet L=0.55U W=10U
Mx2_XMP6_330 OUT x2_n5 VDD_DRV VDD_DRV pfet L=0.55U W=10U
Mx2_XMP6_331 OUT x2_n5 VDD_DRV VDD_DRV pfet L=0.55U W=10U
Mx2_XMP6_332 OUT x2_n5 VDD_DRV VDD_DRV pfet L=0.55U W=10U
Mx2_XMP6_333 OUT x2_n5 VDD_DRV VDD_DRV pfet L=0.55U W=10U
Mx2_XMP6_334 OUT x2_n5 VDD_DRV VDD_DRV pfet L=0.55U W=10U
Mx2_XMP6_335 OUT x2_n5 VDD_DRV VDD_DRV pfet L=0.55U W=10U
Mx2_XMP6_336 OUT x2_n5 VDD_DRV VDD_DRV pfet L=0.55U W=10U
Mx2_XMP6_337 OUT x2_n5 VDD_DRV VDD_DRV pfet L=0.55U W=10U
Mx2_XMP6_338 OUT x2_n5 VDD_DRV VDD_DRV pfet L=0.55U W=10U
Mx2_XMP6_339 OUT x2_n5 VDD_DRV VDD_DRV pfet L=0.55U W=10U
Mx2_XMP6_34 OUT x2_n5 VDD_DRV VDD_DRV pfet L=0.55U W=10U
Mx2_XMP6_340 OUT x2_n5 VDD_DRV VDD_DRV pfet L=0.55U W=10U
Mx2_XMP6_341 OUT x2_n5 VDD_DRV VDD_DRV pfet L=0.55U W=10U
Mx2_XMP6_342 OUT x2_n5 VDD_DRV VDD_DRV pfet L=0.55U W=10U
Mx2_XMP6_343 OUT x2_n5 VDD_DRV VDD_DRV pfet L=0.55U W=10U
Mx2_XMP6_344 OUT x2_n5 VDD_DRV VDD_DRV pfet L=0.55U W=10U
Mx2_XMP6_345 OUT x2_n5 VDD_DRV VDD_DRV pfet L=0.55U W=10U
Mx2_XMP6_346 OUT x2_n5 VDD_DRV VDD_DRV pfet L=0.55U W=10U
Mx2_XMP6_347 OUT x2_n5 VDD_DRV VDD_DRV pfet L=0.55U W=10U
Mx2_XMP6_348 OUT x2_n5 VDD_DRV VDD_DRV pfet L=0.55U W=10U
Mx2_XMP6_349 OUT x2_n5 VDD_DRV VDD_DRV pfet L=0.55U W=10U
Mx2_XMP6_35 OUT x2_n5 VDD_DRV VDD_DRV pfet L=0.55U W=10U
Mx2_XMP6_350 OUT x2_n5 VDD_DRV VDD_DRV pfet L=0.55U W=10U
Mx2_XMP6_351 OUT x2_n5 VDD_DRV VDD_DRV pfet L=0.55U W=10U
Mx2_XMP6_352 OUT x2_n5 VDD_DRV VDD_DRV pfet L=0.55U W=10U
Mx2_XMP6_353 OUT x2_n5 VDD_DRV VDD_DRV pfet L=0.55U W=10U
Mx2_XMP6_354 OUT x2_n5 VDD_DRV VDD_DRV pfet L=0.55U W=10U
Mx2_XMP6_355 OUT x2_n5 VDD_DRV VDD_DRV pfet L=0.55U W=10U
Mx2_XMP6_356 OUT x2_n5 VDD_DRV VDD_DRV pfet L=0.55U W=10U
Mx2_XMP6_357 OUT x2_n5 VDD_DRV VDD_DRV pfet L=0.55U W=10U
Mx2_XMP6_358 OUT x2_n5 VDD_DRV VDD_DRV pfet L=0.55U W=10U
Mx2_XMP6_359 OUT x2_n5 VDD_DRV VDD_DRV pfet L=0.55U W=10U
Mx2_XMP6_36 OUT x2_n5 VDD_DRV VDD_DRV pfet L=0.55U W=10U
Mx2_XMP6_360 OUT x2_n5 VDD_DRV VDD_DRV pfet L=0.55U W=10U
Mx2_XMP6_361 OUT x2_n5 VDD_DRV VDD_DRV pfet L=0.55U W=10U
Mx2_XMP6_362 OUT x2_n5 VDD_DRV VDD_DRV pfet L=0.55U W=10U
Mx2_XMP6_363 OUT x2_n5 VDD_DRV VDD_DRV pfet L=0.55U W=10U
Mx2_XMP6_364 OUT x2_n5 VDD_DRV VDD_DRV pfet L=0.55U W=10U
Mx2_XMP6_365 OUT x2_n5 VDD_DRV VDD_DRV pfet L=0.55U W=10U
Mx2_XMP6_366 OUT x2_n5 VDD_DRV VDD_DRV pfet L=0.55U W=10U
Mx2_XMP6_367 OUT x2_n5 VDD_DRV VDD_DRV pfet L=0.55U W=10U
Mx2_XMP6_368 OUT x2_n5 VDD_DRV VDD_DRV pfet L=0.55U W=10U
Mx2_XMP6_369 OUT x2_n5 VDD_DRV VDD_DRV pfet L=0.55U W=10U
Mx2_XMP6_37 OUT x2_n5 VDD_DRV VDD_DRV pfet L=0.55U W=10U
Mx2_XMP6_370 OUT x2_n5 VDD_DRV VDD_DRV pfet L=0.55U W=10U
Mx2_XMP6_371 OUT x2_n5 VDD_DRV VDD_DRV pfet L=0.55U W=10U
Mx2_XMP6_372 OUT x2_n5 VDD_DRV VDD_DRV pfet L=0.55U W=10U
Mx2_XMP6_373 OUT x2_n5 VDD_DRV VDD_DRV pfet L=0.55U W=10U
Mx2_XMP6_374 OUT x2_n5 VDD_DRV VDD_DRV pfet L=0.55U W=10U
Mx2_XMP6_375 OUT x2_n5 VDD_DRV VDD_DRV pfet L=0.55U W=10U
Mx2_XMP6_376 OUT x2_n5 VDD_DRV VDD_DRV pfet L=0.55U W=10U
Mx2_XMP6_377 OUT x2_n5 VDD_DRV VDD_DRV pfet L=0.55U W=10U
Mx2_XMP6_378 OUT x2_n5 VDD_DRV VDD_DRV pfet L=0.55U W=10U
Mx2_XMP6_379 OUT x2_n5 VDD_DRV VDD_DRV pfet L=0.55U W=10U
Mx2_XMP6_38 OUT x2_n5 VDD_DRV VDD_DRV pfet L=0.55U W=10U
Mx2_XMP6_380 OUT x2_n5 VDD_DRV VDD_DRV pfet L=0.55U W=10U
Mx2_XMP6_381 OUT x2_n5 VDD_DRV VDD_DRV pfet L=0.55U W=10U
Mx2_XMP6_382 OUT x2_n5 VDD_DRV VDD_DRV pfet L=0.55U W=10U
Mx2_XMP6_383 OUT x2_n5 VDD_DRV VDD_DRV pfet L=0.55U W=10U
Mx2_XMP6_384 OUT x2_n5 VDD_DRV VDD_DRV pfet L=0.55U W=10U
Mx2_XMP6_385 OUT x2_n5 VDD_DRV VDD_DRV pfet L=0.55U W=10U
Mx2_XMP6_386 OUT x2_n5 VDD_DRV VDD_DRV pfet L=0.55U W=10U
Mx2_XMP6_387 OUT x2_n5 VDD_DRV VDD_DRV pfet L=0.55U W=10U
Mx2_XMP6_388 OUT x2_n5 VDD_DRV VDD_DRV pfet L=0.55U W=10U
Mx2_XMP6_389 OUT x2_n5 VDD_DRV VDD_DRV pfet L=0.55U W=10U
Mx2_XMP6_39 OUT x2_n5 VDD_DRV VDD_DRV pfet L=0.55U W=10U
Mx2_XMP6_390 OUT x2_n5 VDD_DRV VDD_DRV pfet L=0.55U W=10U
Mx2_XMP6_391 OUT x2_n5 VDD_DRV VDD_DRV pfet L=0.55U W=10U
Mx2_XMP6_392 OUT x2_n5 VDD_DRV VDD_DRV pfet L=0.55U W=10U
Mx2_XMP6_393 OUT x2_n5 VDD_DRV VDD_DRV pfet L=0.55U W=10U
Mx2_XMP6_394 OUT x2_n5 VDD_DRV VDD_DRV pfet L=0.55U W=10U
Mx2_XMP6_395 OUT x2_n5 VDD_DRV VDD_DRV pfet L=0.55U W=10U
Mx2_XMP6_396 OUT x2_n5 VDD_DRV VDD_DRV pfet L=0.55U W=10U
Mx2_XMP6_397 OUT x2_n5 VDD_DRV VDD_DRV pfet L=0.55U W=10U
Mx2_XMP6_398 OUT x2_n5 VDD_DRV VDD_DRV pfet L=0.55U W=10U
Mx2_XMP6_399 OUT x2_n5 VDD_DRV VDD_DRV pfet L=0.55U W=10U
Mx2_XMP6_4 OUT x2_n5 VDD_DRV VDD_DRV pfet L=0.55U W=10U
Mx2_XMP6_40 OUT x2_n5 VDD_DRV VDD_DRV pfet L=0.55U W=10U
Mx2_XMP6_400 OUT x2_n5 VDD_DRV VDD_DRV pfet L=0.55U W=10U
Mx2_XMP6_401 OUT x2_n5 VDD_DRV VDD_DRV pfet L=0.55U W=10U
Mx2_XMP6_402 OUT x2_n5 VDD_DRV VDD_DRV pfet L=0.55U W=10U
Mx2_XMP6_403 OUT x2_n5 VDD_DRV VDD_DRV pfet L=0.55U W=10U
Mx2_XMP6_404 OUT x2_n5 VDD_DRV VDD_DRV pfet L=0.55U W=10U
Mx2_XMP6_405 OUT x2_n5 VDD_DRV VDD_DRV pfet L=0.55U W=10U
Mx2_XMP6_406 OUT x2_n5 VDD_DRV VDD_DRV pfet L=0.55U W=10U
Mx2_XMP6_407 OUT x2_n5 VDD_DRV VDD_DRV pfet L=0.55U W=10U
Mx2_XMP6_408 OUT x2_n5 VDD_DRV VDD_DRV pfet L=0.55U W=10U
Mx2_XMP6_409 OUT x2_n5 VDD_DRV VDD_DRV pfet L=0.55U W=10U
Mx2_XMP6_41 OUT x2_n5 VDD_DRV VDD_DRV pfet L=0.55U W=10U
Mx2_XMP6_410 OUT x2_n5 VDD_DRV VDD_DRV pfet L=0.55U W=10U
Mx2_XMP6_411 OUT x2_n5 VDD_DRV VDD_DRV pfet L=0.55U W=10U
Mx2_XMP6_412 OUT x2_n5 VDD_DRV VDD_DRV pfet L=0.55U W=10U
Mx2_XMP6_413 OUT x2_n5 VDD_DRV VDD_DRV pfet L=0.55U W=10U
Mx2_XMP6_414 OUT x2_n5 VDD_DRV VDD_DRV pfet L=0.55U W=10U
Mx2_XMP6_415 OUT x2_n5 VDD_DRV VDD_DRV pfet L=0.55U W=10U
Mx2_XMP6_416 OUT x2_n5 VDD_DRV VDD_DRV pfet L=0.55U W=10U
Mx2_XMP6_417 OUT x2_n5 VDD_DRV VDD_DRV pfet L=0.55U W=10U
Mx2_XMP6_418 OUT x2_n5 VDD_DRV VDD_DRV pfet L=0.55U W=10U
Mx2_XMP6_419 OUT x2_n5 VDD_DRV VDD_DRV pfet L=0.55U W=10U
Mx2_XMP6_42 OUT x2_n5 VDD_DRV VDD_DRV pfet L=0.55U W=10U
Mx2_XMP6_420 OUT x2_n5 VDD_DRV VDD_DRV pfet L=0.55U W=10U
Mx2_XMP6_421 OUT x2_n5 VDD_DRV VDD_DRV pfet L=0.55U W=10U
Mx2_XMP6_422 OUT x2_n5 VDD_DRV VDD_DRV pfet L=0.55U W=10U
Mx2_XMP6_423 OUT x2_n5 VDD_DRV VDD_DRV pfet L=0.55U W=10U
Mx2_XMP6_424 OUT x2_n5 VDD_DRV VDD_DRV pfet L=0.55U W=10U
Mx2_XMP6_425 OUT x2_n5 VDD_DRV VDD_DRV pfet L=0.55U W=10U
Mx2_XMP6_426 OUT x2_n5 VDD_DRV VDD_DRV pfet L=0.55U W=10U
Mx2_XMP6_427 OUT x2_n5 VDD_DRV VDD_DRV pfet L=0.55U W=10U
Mx2_XMP6_428 OUT x2_n5 VDD_DRV VDD_DRV pfet L=0.55U W=10U
Mx2_XMP6_429 OUT x2_n5 VDD_DRV VDD_DRV pfet L=0.55U W=10U
Mx2_XMP6_43 OUT x2_n5 VDD_DRV VDD_DRV pfet L=0.55U W=10U
Mx2_XMP6_430 OUT x2_n5 VDD_DRV VDD_DRV pfet L=0.55U W=10U
Mx2_XMP6_431 OUT x2_n5 VDD_DRV VDD_DRV pfet L=0.55U W=10U
Mx2_XMP6_432 OUT x2_n5 VDD_DRV VDD_DRV pfet L=0.55U W=10U
Mx2_XMP6_433 OUT x2_n5 VDD_DRV VDD_DRV pfet L=0.55U W=10U
Mx2_XMP6_434 OUT x2_n5 VDD_DRV VDD_DRV pfet L=0.55U W=10U
Mx2_XMP6_435 OUT x2_n5 VDD_DRV VDD_DRV pfet L=0.55U W=10U
Mx2_XMP6_436 OUT x2_n5 VDD_DRV VDD_DRV pfet L=0.55U W=10U
Mx2_XMP6_437 OUT x2_n5 VDD_DRV VDD_DRV pfet L=0.55U W=10U
Mx2_XMP6_438 OUT x2_n5 VDD_DRV VDD_DRV pfet L=0.55U W=10U
Mx2_XMP6_439 OUT x2_n5 VDD_DRV VDD_DRV pfet L=0.55U W=10U
Mx2_XMP6_44 OUT x2_n5 VDD_DRV VDD_DRV pfet L=0.55U W=10U
Mx2_XMP6_440 OUT x2_n5 VDD_DRV VDD_DRV pfet L=0.55U W=10U
Mx2_XMP6_441 OUT x2_n5 VDD_DRV VDD_DRV pfet L=0.55U W=10U
Mx2_XMP6_442 OUT x2_n5 VDD_DRV VDD_DRV pfet L=0.55U W=10U
Mx2_XMP6_443 OUT x2_n5 VDD_DRV VDD_DRV pfet L=0.55U W=10U
Mx2_XMP6_444 OUT x2_n5 VDD_DRV VDD_DRV pfet L=0.55U W=10U
Mx2_XMP6_445 OUT x2_n5 VDD_DRV VDD_DRV pfet L=0.55U W=10U
Mx2_XMP6_446 OUT x2_n5 VDD_DRV VDD_DRV pfet L=0.55U W=10U
Mx2_XMP6_447 OUT x2_n5 VDD_DRV VDD_DRV pfet L=0.55U W=10U
Mx2_XMP6_448 OUT x2_n5 VDD_DRV VDD_DRV pfet L=0.55U W=10U
Mx2_XMP6_449 OUT x2_n5 VDD_DRV VDD_DRV pfet L=0.55U W=10U
Mx2_XMP6_45 OUT x2_n5 VDD_DRV VDD_DRV pfet L=0.55U W=10U
Mx2_XMP6_450 OUT x2_n5 VDD_DRV VDD_DRV pfet L=0.55U W=10U
Mx2_XMP6_451 OUT x2_n5 VDD_DRV VDD_DRV pfet L=0.55U W=10U
Mx2_XMP6_452 OUT x2_n5 VDD_DRV VDD_DRV pfet L=0.55U W=10U
Mx2_XMP6_453 OUT x2_n5 VDD_DRV VDD_DRV pfet L=0.55U W=10U
Mx2_XMP6_454 OUT x2_n5 VDD_DRV VDD_DRV pfet L=0.55U W=10U
Mx2_XMP6_455 OUT x2_n5 VDD_DRV VDD_DRV pfet L=0.55U W=10U
Mx2_XMP6_456 OUT x2_n5 VDD_DRV VDD_DRV pfet L=0.55U W=10U
Mx2_XMP6_457 OUT x2_n5 VDD_DRV VDD_DRV pfet L=0.55U W=10U
Mx2_XMP6_458 OUT x2_n5 VDD_DRV VDD_DRV pfet L=0.55U W=10U
Mx2_XMP6_459 OUT x2_n5 VDD_DRV VDD_DRV pfet L=0.55U W=10U
Mx2_XMP6_46 OUT x2_n5 VDD_DRV VDD_DRV pfet L=0.55U W=10U
Mx2_XMP6_460 OUT x2_n5 VDD_DRV VDD_DRV pfet L=0.55U W=10U
Mx2_XMP6_461 OUT x2_n5 VDD_DRV VDD_DRV pfet L=0.55U W=10U
Mx2_XMP6_462 OUT x2_n5 VDD_DRV VDD_DRV pfet L=0.55U W=10U
Mx2_XMP6_463 OUT x2_n5 VDD_DRV VDD_DRV pfet L=0.55U W=10U
Mx2_XMP6_464 OUT x2_n5 VDD_DRV VDD_DRV pfet L=0.55U W=10U
Mx2_XMP6_465 OUT x2_n5 VDD_DRV VDD_DRV pfet L=0.55U W=10U
Mx2_XMP6_466 OUT x2_n5 VDD_DRV VDD_DRV pfet L=0.55U W=10U
Mx2_XMP6_467 OUT x2_n5 VDD_DRV VDD_DRV pfet L=0.55U W=10U
Mx2_XMP6_468 OUT x2_n5 VDD_DRV VDD_DRV pfet L=0.55U W=10U
Mx2_XMP6_469 OUT x2_n5 VDD_DRV VDD_DRV pfet L=0.55U W=10U
Mx2_XMP6_47 OUT x2_n5 VDD_DRV VDD_DRV pfet L=0.55U W=10U
Mx2_XMP6_470 OUT x2_n5 VDD_DRV VDD_DRV pfet L=0.55U W=10U
Mx2_XMP6_471 OUT x2_n5 VDD_DRV VDD_DRV pfet L=0.55U W=10U
Mx2_XMP6_472 OUT x2_n5 VDD_DRV VDD_DRV pfet L=0.55U W=10U
Mx2_XMP6_473 OUT x2_n5 VDD_DRV VDD_DRV pfet L=0.55U W=10U
Mx2_XMP6_474 OUT x2_n5 VDD_DRV VDD_DRV pfet L=0.55U W=10U
Mx2_XMP6_475 OUT x2_n5 VDD_DRV VDD_DRV pfet L=0.55U W=10U
Mx2_XMP6_476 OUT x2_n5 VDD_DRV VDD_DRV pfet L=0.55U W=10U
Mx2_XMP6_477 OUT x2_n5 VDD_DRV VDD_DRV pfet L=0.55U W=10U
Mx2_XMP6_478 OUT x2_n5 VDD_DRV VDD_DRV pfet L=0.55U W=10U
Mx2_XMP6_479 OUT x2_n5 VDD_DRV VDD_DRV pfet L=0.55U W=10U
Mx2_XMP6_48 OUT x2_n5 VDD_DRV VDD_DRV pfet L=0.55U W=10U
Mx2_XMP6_480 OUT x2_n5 VDD_DRV VDD_DRV pfet L=0.55U W=10U
Mx2_XMP6_481 OUT x2_n5 VDD_DRV VDD_DRV pfet L=0.55U W=10U
Mx2_XMP6_482 OUT x2_n5 VDD_DRV VDD_DRV pfet L=0.55U W=10U
Mx2_XMP6_483 OUT x2_n5 VDD_DRV VDD_DRV pfet L=0.55U W=10U
Mx2_XMP6_484 OUT x2_n5 VDD_DRV VDD_DRV pfet L=0.55U W=10U
Mx2_XMP6_485 OUT x2_n5 VDD_DRV VDD_DRV pfet L=0.55U W=10U
Mx2_XMP6_486 OUT x2_n5 VDD_DRV VDD_DRV pfet L=0.55U W=10U
Mx2_XMP6_487 OUT x2_n5 VDD_DRV VDD_DRV pfet L=0.55U W=10U
Mx2_XMP6_488 OUT x2_n5 VDD_DRV VDD_DRV pfet L=0.55U W=10U
Mx2_XMP6_489 OUT x2_n5 VDD_DRV VDD_DRV pfet L=0.55U W=10U
Mx2_XMP6_49 OUT x2_n5 VDD_DRV VDD_DRV pfet L=0.55U W=10U
Mx2_XMP6_490 OUT x2_n5 VDD_DRV VDD_DRV pfet L=0.55U W=10U
Mx2_XMP6_491 OUT x2_n5 VDD_DRV VDD_DRV pfet L=0.55U W=10U
Mx2_XMP6_492 OUT x2_n5 VDD_DRV VDD_DRV pfet L=0.55U W=10U
Mx2_XMP6_493 OUT x2_n5 VDD_DRV VDD_DRV pfet L=0.55U W=10U
Mx2_XMP6_494 OUT x2_n5 VDD_DRV VDD_DRV pfet L=0.55U W=10U
Mx2_XMP6_495 OUT x2_n5 VDD_DRV VDD_DRV pfet L=0.55U W=10U
Mx2_XMP6_496 OUT x2_n5 VDD_DRV VDD_DRV pfet L=0.55U W=10U
Mx2_XMP6_497 OUT x2_n5 VDD_DRV VDD_DRV pfet L=0.55U W=10U
Mx2_XMP6_498 OUT x2_n5 VDD_DRV VDD_DRV pfet L=0.55U W=10U
Mx2_XMP6_499 OUT x2_n5 VDD_DRV VDD_DRV pfet L=0.55U W=10U
Mx2_XMP6_5 OUT x2_n5 VDD_DRV VDD_DRV pfet L=0.55U W=10U
Mx2_XMP6_50 OUT x2_n5 VDD_DRV VDD_DRV pfet L=0.55U W=10U
Mx2_XMP6_51 OUT x2_n5 VDD_DRV VDD_DRV pfet L=0.55U W=10U
Mx2_XMP6_52 OUT x2_n5 VDD_DRV VDD_DRV pfet L=0.55U W=10U
Mx2_XMP6_53 OUT x2_n5 VDD_DRV VDD_DRV pfet L=0.55U W=10U
Mx2_XMP6_54 OUT x2_n5 VDD_DRV VDD_DRV pfet L=0.55U W=10U
Mx2_XMP6_55 OUT x2_n5 VDD_DRV VDD_DRV pfet L=0.55U W=10U
Mx2_XMP6_56 OUT x2_n5 VDD_DRV VDD_DRV pfet L=0.55U W=10U
Mx2_XMP6_57 OUT x2_n5 VDD_DRV VDD_DRV pfet L=0.55U W=10U
Mx2_XMP6_58 OUT x2_n5 VDD_DRV VDD_DRV pfet L=0.55U W=10U
Mx2_XMP6_59 OUT x2_n5 VDD_DRV VDD_DRV pfet L=0.55U W=10U
Mx2_XMP6_6 OUT x2_n5 VDD_DRV VDD_DRV pfet L=0.55U W=10U
Mx2_XMP6_60 OUT x2_n5 VDD_DRV VDD_DRV pfet L=0.55U W=10U
Mx2_XMP6_61 OUT x2_n5 VDD_DRV VDD_DRV pfet L=0.55U W=10U
Mx2_XMP6_62 OUT x2_n5 VDD_DRV VDD_DRV pfet L=0.55U W=10U
Mx2_XMP6_63 OUT x2_n5 VDD_DRV VDD_DRV pfet L=0.55U W=10U
Mx2_XMP6_64 OUT x2_n5 VDD_DRV VDD_DRV pfet L=0.55U W=10U
Mx2_XMP6_65 OUT x2_n5 VDD_DRV VDD_DRV pfet L=0.55U W=10U
Mx2_XMP6_66 OUT x2_n5 VDD_DRV VDD_DRV pfet L=0.55U W=10U
Mx2_XMP6_67 OUT x2_n5 VDD_DRV VDD_DRV pfet L=0.55U W=10U
Mx2_XMP6_68 OUT x2_n5 VDD_DRV VDD_DRV pfet L=0.55U W=10U
Mx2_XMP6_69 OUT x2_n5 VDD_DRV VDD_DRV pfet L=0.55U W=10U
Mx2_XMP6_7 OUT x2_n5 VDD_DRV VDD_DRV pfet L=0.55U W=10U
Mx2_XMP6_70 OUT x2_n5 VDD_DRV VDD_DRV pfet L=0.55U W=10U
Mx2_XMP6_71 OUT x2_n5 VDD_DRV VDD_DRV pfet L=0.55U W=10U
Mx2_XMP6_72 OUT x2_n5 VDD_DRV VDD_DRV pfet L=0.55U W=10U
Mx2_XMP6_73 OUT x2_n5 VDD_DRV VDD_DRV pfet L=0.55U W=10U
Mx2_XMP6_74 OUT x2_n5 VDD_DRV VDD_DRV pfet L=0.55U W=10U
Mx2_XMP6_75 OUT x2_n5 VDD_DRV VDD_DRV pfet L=0.55U W=10U
Mx2_XMP6_76 OUT x2_n5 VDD_DRV VDD_DRV pfet L=0.55U W=10U
Mx2_XMP6_77 OUT x2_n5 VDD_DRV VDD_DRV pfet L=0.55U W=10U
Mx2_XMP6_78 OUT x2_n5 VDD_DRV VDD_DRV pfet L=0.55U W=10U
Mx2_XMP6_79 OUT x2_n5 VDD_DRV VDD_DRV pfet L=0.55U W=10U
Mx2_XMP6_8 OUT x2_n5 VDD_DRV VDD_DRV pfet L=0.55U W=10U
Mx2_XMP6_80 OUT x2_n5 VDD_DRV VDD_DRV pfet L=0.55U W=10U
Mx2_XMP6_81 OUT x2_n5 VDD_DRV VDD_DRV pfet L=0.55U W=10U
Mx2_XMP6_82 OUT x2_n5 VDD_DRV VDD_DRV pfet L=0.55U W=10U
Mx2_XMP6_83 OUT x2_n5 VDD_DRV VDD_DRV pfet L=0.55U W=10U
Mx2_XMP6_84 OUT x2_n5 VDD_DRV VDD_DRV pfet L=0.55U W=10U
Mx2_XMP6_85 OUT x2_n5 VDD_DRV VDD_DRV pfet L=0.55U W=10U
Mx2_XMP6_86 OUT x2_n5 VDD_DRV VDD_DRV pfet L=0.55U W=10U
Mx2_XMP6_87 OUT x2_n5 VDD_DRV VDD_DRV pfet L=0.55U W=10U
Mx2_XMP6_88 OUT x2_n5 VDD_DRV VDD_DRV pfet L=0.55U W=10U
Mx2_XMP6_89 OUT x2_n5 VDD_DRV VDD_DRV pfet L=0.55U W=10U
Mx2_XMP6_9 OUT x2_n5 VDD_DRV VDD_DRV pfet L=0.55U W=10U
Mx2_XMP6_90 OUT x2_n5 VDD_DRV VDD_DRV pfet L=0.55U W=10U
Mx2_XMP6_91 OUT x2_n5 VDD_DRV VDD_DRV pfet L=0.55U W=10U
Mx2_XMP6_92 OUT x2_n5 VDD_DRV VDD_DRV pfet L=0.55U W=10U
Mx2_XMP6_93 OUT x2_n5 VDD_DRV VDD_DRV pfet L=0.55U W=10U
Mx2_XMP6_94 OUT x2_n5 VDD_DRV VDD_DRV pfet L=0.55U W=10U
Mx2_XMP6_95 OUT x2_n5 VDD_DRV VDD_DRV pfet L=0.55U W=10U
Mx2_XMP6_96 OUT x2_n5 VDD_DRV VDD_DRV pfet L=0.55U W=10U
Mx2_XMP6_97 OUT x2_n5 VDD_DRV VDD_DRV pfet L=0.55U W=10U
Mx2_XMP6_98 OUT x2_n5 VDD_DRV VDD_DRV pfet L=0.55U W=10U
Mx2_XMP6_99 OUT x2_n5 VDD_DRV VDD_DRV pfet L=0.55U W=10U
.ENDS gate_driver_core
