* extracted by klt extract --deck gf180mcu

* cell gate_driver_core
* pin GND_DRV,GND_LOGIC
* pin IN
* pin IN_DRV
* pin OUT
* pin VDD_DRV
* pin VDD_LOGIC
* pin x1_inb
* pin x1_na
* pin x1_nb
* pin x1_nbuf1
* pin x1_nca
* pin x1_ncb
* pin x2_n1
* pin x2_n2
* pin x2_n3
* pin x2_n4
* pin x2_n5
.SUBCKT gate_driver_core GND_DRV|GND_LOGIC IN IN_DRV OUT VDD_DRV VDD_LOGIC
+ x1_inb x1_na x1_nb x1_nbuf1 x1_nca x1_ncb x2_n1 x2_n2 x2_n3 x2_n4 x2_n5
* device instance $1 r0 *1 0.56,2.5 nfet
M$1 x1_inb IN GND_DRV|GND_LOGIC GND_DRV|GND_LOGIC nfet L=0.28U W=5U AS=2.1P
+ AD=2.1P PS=10.84U PD=10.84U
* device instance $2 r0 *1 0.56,33.34 nfet
M$2 x1_na IN GND_DRV|GND_LOGIC GND_DRV|GND_LOGIC nfet L=0.28U W=20U AS=8.4P
+ AD=8.4P PS=40.84U PD=40.84U
* device instance $3 r0 *1 0.56,57.36 nfet
M$3 x1_nb x1_inb GND_DRV|GND_LOGIC GND_DRV|GND_LOGIC nfet L=0.28U W=20U AS=8.4P
+ AD=8.4P PS=40.84U PD=40.84U
* device instance $4 r0 *1 0.77,98.18 nfet
M$4 x1_nca VDD_LOGIC x1_na GND_DRV|GND_LOGIC nfet L=0.7U W=20U AS=8.4P AD=8.4P
+ PS=40.84U PD=40.84U
* device instance $5 r0 *1 0.77,122.2 nfet
M$5 x1_ncb VDD_LOGIC x1_nb GND_DRV|GND_LOGIC nfet L=0.7U W=20U AS=8.4P AD=8.4P
+ PS=40.84U PD=40.84U
* device instance $6 r0 *1 0.77,162.68 nfet
M$6 x1_nbuf1 x1_ncb GND_DRV|GND_LOGIC GND_DRV|GND_LOGIC nfet L=0.7U W=5U
+ AS=2.1P AD=2.1P PS=10.84U PD=10.84U
* device instance $7 r0 *1 0.77,196.02 nfet
M$7 IN_DRV x1_nbuf1 GND_DRV|GND_LOGIC GND_DRV|GND_LOGIC nfet L=0.7U W=15U
+ AS=6.3P AD=6.3P PS=30.84U PD=30.84U
* device instance $8 r0 *1 0.77,217.26 nfet
M$8 x2_n1 IN_DRV GND_DRV|GND_LOGIC GND_DRV|GND_LOGIC nfet L=0.7U W=2U AS=0.84P
+ AD=0.84P PS=4.84U PD=4.84U
* device instance $9 r0 *1 0.77,248.6 nfet
M$9 x2_n2 x2_n1 GND_DRV|GND_LOGIC GND_DRV|GND_LOGIC nfet L=0.7U W=8U AS=3.36P
+ AD=3.36P PS=16.84U PD=16.84U
* device instance $10 r0 *1 0.77,350.44 nfet
M$10 x2_n3 x2_n2 GND_DRV|GND_LOGIC GND_DRV|GND_LOGIC nfet L=0.7U W=33U
+ AS=13.86P AD=13.86P PS=66.84U PD=66.84U
* device instance $11 r0 *1 0.77,392.74 nfet
M$11 x2_n4 x2_n3 GND_DRV|GND_LOGIC GND_DRV|GND_LOGIC nfet L=0.7U W=10U AS=4.2P
+ AD=2.1P PS=20.84U PD=10.42U
* device instance $12 r0 *1 1.89,392.74 nfet
M$12 GND_DRV|GND_LOGIC x2_n3 x2_n4 GND_DRV|GND_LOGIC nfet L=0.7U W=10U AS=2.1P
+ AD=2.1P PS=10.42U PD=10.42U
* device instance $13 r0 *1 3.01,392.74 nfet
M$13 x2_n4 x2_n3 GND_DRV|GND_LOGIC GND_DRV|GND_LOGIC nfet L=0.7U W=10U AS=2.1P
+ AD=2.1P PS=10.42U PD=10.42U
* device instance $14 r0 *1 4.13,392.74 nfet
M$14 GND_DRV|GND_LOGIC x2_n3 x2_n4 GND_DRV|GND_LOGIC nfet L=0.7U W=10U AS=2.1P
+ AD=2.1P PS=10.42U PD=10.42U
* device instance $15 r0 *1 5.25,392.74 nfet
M$15 x2_n4 x2_n3 GND_DRV|GND_LOGIC GND_DRV|GND_LOGIC nfet L=0.7U W=10U AS=2.1P
+ AD=2.1P PS=10.42U PD=10.42U
* device instance $16 r0 *1 6.37,392.74 nfet
M$16 GND_DRV|GND_LOGIC x2_n3 x2_n4 GND_DRV|GND_LOGIC nfet L=0.7U W=10U AS=2.1P
+ AD=2.1P PS=10.42U PD=10.42U
* device instance $17 r0 *1 7.49,392.74 nfet
M$17 x2_n4 x2_n3 GND_DRV|GND_LOGIC GND_DRV|GND_LOGIC nfet L=0.7U W=10U AS=2.1P
+ AD=2.1P PS=10.42U PD=10.42U
* device instance $18 r0 *1 8.61,392.74 nfet
M$18 GND_DRV|GND_LOGIC x2_n3 x2_n4 GND_DRV|GND_LOGIC nfet L=0.7U W=10U AS=2.1P
+ AD=2.1P PS=10.42U PD=10.42U
* device instance $19 r0 *1 9.73,392.74 nfet
M$19 x2_n4 x2_n3 GND_DRV|GND_LOGIC GND_DRV|GND_LOGIC nfet L=0.7U W=10U AS=2.1P
+ AD=2.1P PS=10.42U PD=10.42U
* device instance $20 r0 *1 10.85,392.74 nfet
M$20 GND_DRV|GND_LOGIC x2_n3 x2_n4 GND_DRV|GND_LOGIC nfet L=0.7U W=10U AS=2.1P
+ AD=2.1P PS=10.42U PD=10.42U
* device instance $21 r0 *1 11.97,392.74 nfet
M$21 x2_n4 x2_n3 GND_DRV|GND_LOGIC GND_DRV|GND_LOGIC nfet L=0.7U W=10U AS=2.1P
+ AD=2.1P PS=10.42U PD=10.42U
* device instance $22 r0 *1 13.09,392.74 nfet
M$22 GND_DRV|GND_LOGIC x2_n3 x2_n4 GND_DRV|GND_LOGIC nfet L=0.7U W=10U AS=2.1P
+ AD=2.1P PS=10.42U PD=10.42U
* device instance $23 r0 *1 14.21,392.74 nfet
M$23 x2_n4 x2_n3 GND_DRV|GND_LOGIC GND_DRV|GND_LOGIC nfet L=0.7U W=10U AS=2.1P
+ AD=2.1P PS=10.42U PD=10.42U
* device instance $24 r0 *1 15.33,392.74 nfet
M$24 GND_DRV|GND_LOGIC x2_n3 x2_n4 GND_DRV|GND_LOGIC nfet L=0.7U W=10U AS=2.1P
+ AD=4.2P PS=10.42U PD=20.84U
* device instance $25 r0 *1 0.77,424.36 nfet
M$25 x2_n5 x2_n4 GND_DRV|GND_LOGIC GND_DRV|GND_LOGIC nfet L=0.7U W=10U AS=4.2P
+ AD=2.1P PS=20.84U PD=10.42U
* device instance $26 r0 *1 1.89,424.36 nfet
M$26 GND_DRV|GND_LOGIC x2_n4 x2_n5 GND_DRV|GND_LOGIC nfet L=0.7U W=10U AS=2.1P
+ AD=2.1P PS=10.42U PD=10.42U
* device instance $27 r0 *1 3.01,424.36 nfet
M$27 x2_n5 x2_n4 GND_DRV|GND_LOGIC GND_DRV|GND_LOGIC nfet L=0.7U W=10U AS=2.1P
+ AD=2.1P PS=10.42U PD=10.42U
* device instance $28 r0 *1 4.13,424.36 nfet
M$28 GND_DRV|GND_LOGIC x2_n4 x2_n5 GND_DRV|GND_LOGIC nfet L=0.7U W=10U AS=2.1P
+ AD=2.1P PS=10.42U PD=10.42U
* device instance $29 r0 *1 5.25,424.36 nfet
M$29 x2_n5 x2_n4 GND_DRV|GND_LOGIC GND_DRV|GND_LOGIC nfet L=0.7U W=10U AS=2.1P
+ AD=2.1P PS=10.42U PD=10.42U
* device instance $30 r0 *1 6.37,424.36 nfet
M$30 GND_DRV|GND_LOGIC x2_n4 x2_n5 GND_DRV|GND_LOGIC nfet L=0.7U W=10U AS=2.1P
+ AD=2.1P PS=10.42U PD=10.42U
* device instance $31 r0 *1 7.49,424.36 nfet
M$31 x2_n5 x2_n4 GND_DRV|GND_LOGIC GND_DRV|GND_LOGIC nfet L=0.7U W=10U AS=2.1P
+ AD=2.1P PS=10.42U PD=10.42U
* device instance $32 r0 *1 8.61,424.36 nfet
M$32 GND_DRV|GND_LOGIC x2_n4 x2_n5 GND_DRV|GND_LOGIC nfet L=0.7U W=10U AS=2.1P
+ AD=2.1P PS=10.42U PD=10.42U
* device instance $33 r0 *1 9.73,424.36 nfet
M$33 x2_n5 x2_n4 GND_DRV|GND_LOGIC GND_DRV|GND_LOGIC nfet L=0.7U W=10U AS=2.1P
+ AD=2.1P PS=10.42U PD=10.42U
* device instance $34 r0 *1 10.85,424.36 nfet
M$34 GND_DRV|GND_LOGIC x2_n4 x2_n5 GND_DRV|GND_LOGIC nfet L=0.7U W=10U AS=2.1P
+ AD=2.1P PS=10.42U PD=10.42U
* device instance $35 r0 *1 11.97,424.36 nfet
M$35 x2_n5 x2_n4 GND_DRV|GND_LOGIC GND_DRV|GND_LOGIC nfet L=0.7U W=10U AS=2.1P
+ AD=2.1P PS=10.42U PD=10.42U
* device instance $36 r0 *1 13.09,424.36 nfet
M$36 GND_DRV|GND_LOGIC x2_n4 x2_n5 GND_DRV|GND_LOGIC nfet L=0.7U W=10U AS=2.1P
+ AD=2.1P PS=10.42U PD=10.42U
* device instance $37 r0 *1 14.21,424.36 nfet
M$37 x2_n5 x2_n4 GND_DRV|GND_LOGIC GND_DRV|GND_LOGIC nfet L=0.7U W=10U AS=2.1P
+ AD=2.1P PS=10.42U PD=10.42U
* device instance $38 r0 *1 15.33,424.36 nfet
M$38 GND_DRV|GND_LOGIC x2_n4 x2_n5 GND_DRV|GND_LOGIC nfet L=0.7U W=10U AS=2.1P
+ AD=2.1P PS=10.42U PD=10.42U
* device instance $39 r0 *1 16.45,424.36 nfet
M$39 x2_n5 x2_n4 GND_DRV|GND_LOGIC GND_DRV|GND_LOGIC nfet L=0.7U W=10U AS=2.1P
+ AD=2.1P PS=10.42U PD=10.42U
* device instance $40 r0 *1 17.57,424.36 nfet
M$40 GND_DRV|GND_LOGIC x2_n4 x2_n5 GND_DRV|GND_LOGIC nfet L=0.7U W=10U AS=2.1P
+ AD=2.1P PS=10.42U PD=10.42U
* device instance $41 r0 *1 18.69,424.36 nfet
M$41 x2_n5 x2_n4 GND_DRV|GND_LOGIC GND_DRV|GND_LOGIC nfet L=0.7U W=10U AS=2.1P
+ AD=2.1P PS=10.42U PD=10.42U
* device instance $42 r0 *1 19.81,424.36 nfet
M$42 GND_DRV|GND_LOGIC x2_n4 x2_n5 GND_DRV|GND_LOGIC nfet L=0.7U W=10U AS=2.1P
+ AD=2.1P PS=10.42U PD=10.42U
* device instance $43 r0 *1 20.93,424.36 nfet
M$43 x2_n5 x2_n4 GND_DRV|GND_LOGIC GND_DRV|GND_LOGIC nfet L=0.7U W=10U AS=2.1P
+ AD=2.1P PS=10.42U PD=10.42U
* device instance $44 r0 *1 22.05,424.36 nfet
M$44 GND_DRV|GND_LOGIC x2_n4 x2_n5 GND_DRV|GND_LOGIC nfet L=0.7U W=10U AS=2.1P
+ AD=2.1P PS=10.42U PD=10.42U
* device instance $45 r0 *1 23.17,424.36 nfet
M$45 x2_n5 x2_n4 GND_DRV|GND_LOGIC GND_DRV|GND_LOGIC nfet L=0.7U W=10U AS=2.1P
+ AD=2.1P PS=10.42U PD=10.42U
* device instance $46 r0 *1 24.29,424.36 nfet
M$46 GND_DRV|GND_LOGIC x2_n4 x2_n5 GND_DRV|GND_LOGIC nfet L=0.7U W=10U AS=2.1P
+ AD=2.1P PS=10.42U PD=10.42U
* device instance $47 r0 *1 25.41,424.36 nfet
M$47 x2_n5 x2_n4 GND_DRV|GND_LOGIC GND_DRV|GND_LOGIC nfet L=0.7U W=10U AS=2.1P
+ AD=2.1P PS=10.42U PD=10.42U
* device instance $48 r0 *1 26.53,424.36 nfet
M$48 GND_DRV|GND_LOGIC x2_n4 x2_n5 GND_DRV|GND_LOGIC nfet L=0.7U W=10U AS=2.1P
+ AD=2.1P PS=10.42U PD=10.42U
* device instance $49 r0 *1 27.65,424.36 nfet
M$49 x2_n5 x2_n4 GND_DRV|GND_LOGIC GND_DRV|GND_LOGIC nfet L=0.7U W=10U AS=2.1P
+ AD=2.1P PS=10.42U PD=10.42U
* device instance $50 r0 *1 28.77,424.36 nfet
M$50 GND_DRV|GND_LOGIC x2_n4 x2_n5 GND_DRV|GND_LOGIC nfet L=0.7U W=10U AS=2.1P
+ AD=2.1P PS=10.42U PD=10.42U
* device instance $51 r0 *1 29.89,424.36 nfet
M$51 x2_n5 x2_n4 GND_DRV|GND_LOGIC GND_DRV|GND_LOGIC nfet L=0.7U W=10U AS=2.1P
+ AD=2.1P PS=10.42U PD=10.42U
* device instance $52 r0 *1 31.01,424.36 nfet
M$52 GND_DRV|GND_LOGIC x2_n4 x2_n5 GND_DRV|GND_LOGIC nfet L=0.7U W=10U AS=2.1P
+ AD=2.1P PS=10.42U PD=10.42U
* device instance $53 r0 *1 32.13,424.36 nfet
M$53 x2_n5 x2_n4 GND_DRV|GND_LOGIC GND_DRV|GND_LOGIC nfet L=0.7U W=10U AS=2.1P
+ AD=2.1P PS=10.42U PD=10.42U
* device instance $54 r0 *1 33.25,424.36 nfet
M$54 GND_DRV|GND_LOGIC x2_n4 x2_n5 GND_DRV|GND_LOGIC nfet L=0.7U W=10U AS=2.1P
+ AD=2.1P PS=10.42U PD=10.42U
* device instance $55 r0 *1 34.37,424.36 nfet
M$55 x2_n5 x2_n4 GND_DRV|GND_LOGIC GND_DRV|GND_LOGIC nfet L=0.7U W=10U AS=2.1P
+ AD=2.1P PS=10.42U PD=10.42U
* device instance $56 r0 *1 35.49,424.36 nfet
M$56 GND_DRV|GND_LOGIC x2_n4 x2_n5 GND_DRV|GND_LOGIC nfet L=0.7U W=10U AS=2.1P
+ AD=2.1P PS=10.42U PD=10.42U
* device instance $57 r0 *1 36.61,424.36 nfet
M$57 x2_n5 x2_n4 GND_DRV|GND_LOGIC GND_DRV|GND_LOGIC nfet L=0.7U W=10U AS=2.1P
+ AD=2.1P PS=10.42U PD=10.42U
* device instance $58 r0 *1 37.73,424.36 nfet
M$58 GND_DRV|GND_LOGIC x2_n4 x2_n5 GND_DRV|GND_LOGIC nfet L=0.7U W=10U AS=2.1P
+ AD=2.1P PS=10.42U PD=10.42U
* device instance $59 r0 *1 38.85,424.36 nfet
M$59 x2_n5 x2_n4 GND_DRV|GND_LOGIC GND_DRV|GND_LOGIC nfet L=0.7U W=10U AS=2.1P
+ AD=2.1P PS=10.42U PD=10.42U
* device instance $60 r0 *1 39.97,424.36 nfet
M$60 GND_DRV|GND_LOGIC x2_n4 x2_n5 GND_DRV|GND_LOGIC nfet L=0.7U W=10U AS=2.1P
+ AD=2.1P PS=10.42U PD=10.42U
* device instance $61 r0 *1 41.09,424.36 nfet
M$61 x2_n5 x2_n4 GND_DRV|GND_LOGIC GND_DRV|GND_LOGIC nfet L=0.7U W=10U AS=2.1P
+ AD=2.1P PS=10.42U PD=10.42U
* device instance $62 r0 *1 42.21,424.36 nfet
M$62 GND_DRV|GND_LOGIC x2_n4 x2_n5 GND_DRV|GND_LOGIC nfet L=0.7U W=10U AS=2.1P
+ AD=2.1P PS=10.42U PD=10.42U
* device instance $63 r0 *1 43.33,424.36 nfet
M$63 x2_n5 x2_n4 GND_DRV|GND_LOGIC GND_DRV|GND_LOGIC nfet L=0.7U W=10U AS=2.1P
+ AD=2.1P PS=10.42U PD=10.42U
* device instance $64 r0 *1 44.45,424.36 nfet
M$64 GND_DRV|GND_LOGIC x2_n4 x2_n5 GND_DRV|GND_LOGIC nfet L=0.7U W=10U AS=2.1P
+ AD=2.1P PS=10.42U PD=10.42U
* device instance $65 r0 *1 45.57,424.36 nfet
M$65 x2_n5 x2_n4 GND_DRV|GND_LOGIC GND_DRV|GND_LOGIC nfet L=0.7U W=10U AS=2.1P
+ AD=2.1P PS=10.42U PD=10.42U
* device instance $66 r0 *1 46.69,424.36 nfet
M$66 GND_DRV|GND_LOGIC x2_n4 x2_n5 GND_DRV|GND_LOGIC nfet L=0.7U W=10U AS=2.1P
+ AD=2.1P PS=10.42U PD=10.42U
* device instance $67 r0 *1 47.81,424.36 nfet
M$67 x2_n5 x2_n4 GND_DRV|GND_LOGIC GND_DRV|GND_LOGIC nfet L=0.7U W=10U AS=2.1P
+ AD=2.1P PS=10.42U PD=10.42U
* device instance $68 r0 *1 48.93,424.36 nfet
M$68 GND_DRV|GND_LOGIC x2_n4 x2_n5 GND_DRV|GND_LOGIC nfet L=0.7U W=10U AS=2.1P
+ AD=2.1P PS=10.42U PD=10.42U
* device instance $69 r0 *1 50.05,424.36 nfet
M$69 x2_n5 x2_n4 GND_DRV|GND_LOGIC GND_DRV|GND_LOGIC nfet L=0.7U W=10U AS=2.1P
+ AD=2.1P PS=10.42U PD=10.42U
* device instance $70 r0 *1 51.17,424.36 nfet
M$70 GND_DRV|GND_LOGIC x2_n4 x2_n5 GND_DRV|GND_LOGIC nfet L=0.7U W=10U AS=2.1P
+ AD=2.1P PS=10.42U PD=10.42U
* device instance $71 r0 *1 52.29,424.36 nfet
M$71 x2_n5 x2_n4 GND_DRV|GND_LOGIC GND_DRV|GND_LOGIC nfet L=0.7U W=10U AS=2.1P
+ AD=2.1P PS=10.42U PD=10.42U
* device instance $72 r0 *1 53.41,424.36 nfet
M$72 GND_DRV|GND_LOGIC x2_n4 x2_n5 GND_DRV|GND_LOGIC nfet L=0.7U W=10U AS=2.1P
+ AD=2.1P PS=10.42U PD=10.42U
* device instance $73 r0 *1 54.53,424.36 nfet
M$73 x2_n5 x2_n4 GND_DRV|GND_LOGIC GND_DRV|GND_LOGIC nfet L=0.7U W=10U AS=2.1P
+ AD=2.1P PS=10.42U PD=10.42U
* device instance $74 r0 *1 55.65,424.36 nfet
M$74 GND_DRV|GND_LOGIC x2_n4 x2_n5 GND_DRV|GND_LOGIC nfet L=0.7U W=10U AS=2.1P
+ AD=2.1P PS=10.42U PD=10.42U
* device instance $75 r0 *1 56.77,424.36 nfet
M$75 x2_n5 x2_n4 GND_DRV|GND_LOGIC GND_DRV|GND_LOGIC nfet L=0.7U W=10U AS=2.1P
+ AD=2.1P PS=10.42U PD=10.42U
* device instance $76 r0 *1 57.89,424.36 nfet
M$76 GND_DRV|GND_LOGIC x2_n4 x2_n5 GND_DRV|GND_LOGIC nfet L=0.7U W=10U AS=2.1P
+ AD=2.1P PS=10.42U PD=10.42U
* device instance $77 r0 *1 59.01,424.36 nfet
M$77 x2_n5 x2_n4 GND_DRV|GND_LOGIC GND_DRV|GND_LOGIC nfet L=0.7U W=10U AS=2.1P
+ AD=2.1P PS=10.42U PD=10.42U
* device instance $78 r0 *1 60.13,424.36 nfet
M$78 GND_DRV|GND_LOGIC x2_n4 x2_n5 GND_DRV|GND_LOGIC nfet L=0.7U W=10U AS=2.1P
+ AD=2.1P PS=10.42U PD=10.42U
* device instance $79 r0 *1 61.25,424.36 nfet
M$79 x2_n5 x2_n4 GND_DRV|GND_LOGIC GND_DRV|GND_LOGIC nfet L=0.7U W=10U AS=2.1P
+ AD=4.2P PS=10.42U PD=20.84U
* device instance $80 r0 *1 185.57,455.98 nfet
M$80 GND_DRV|GND_LOGIC x2_n5 OUT GND_DRV|GND_LOGIC nfet L=0.7U W=10U AS=2.1P
+ AD=2.1P PS=10.42U PD=10.42U
* device instance $81 r0 *1 186.69,455.98 nfet
M$81 OUT x2_n5 GND_DRV|GND_LOGIC GND_DRV|GND_LOGIC nfet L=0.7U W=10U AS=2.1P
+ AD=2.1P PS=10.42U PD=10.42U
* device instance $82 r0 *1 187.81,455.98 nfet
M$82 GND_DRV|GND_LOGIC x2_n5 OUT GND_DRV|GND_LOGIC nfet L=0.7U W=10U AS=2.1P
+ AD=2.1P PS=10.42U PD=10.42U
* device instance $83 r0 *1 188.93,455.98 nfet
M$83 OUT x2_n5 GND_DRV|GND_LOGIC GND_DRV|GND_LOGIC nfet L=0.7U W=10U AS=2.1P
+ AD=2.1P PS=10.42U PD=10.42U
* device instance $84 r0 *1 190.05,455.98 nfet
M$84 GND_DRV|GND_LOGIC x2_n5 OUT GND_DRV|GND_LOGIC nfet L=0.7U W=10U AS=2.1P
+ AD=2.1P PS=10.42U PD=10.42U
* device instance $85 r0 *1 191.17,455.98 nfet
M$85 OUT x2_n5 GND_DRV|GND_LOGIC GND_DRV|GND_LOGIC nfet L=0.7U W=10U AS=2.1P
+ AD=2.1P PS=10.42U PD=10.42U
* device instance $86 r0 *1 192.29,455.98 nfet
M$86 GND_DRV|GND_LOGIC x2_n5 OUT GND_DRV|GND_LOGIC nfet L=0.7U W=10U AS=2.1P
+ AD=2.1P PS=10.42U PD=10.42U
* device instance $87 r0 *1 193.41,455.98 nfet
M$87 OUT x2_n5 GND_DRV|GND_LOGIC GND_DRV|GND_LOGIC nfet L=0.7U W=10U AS=2.1P
+ AD=2.1P PS=10.42U PD=10.42U
* device instance $88 r0 *1 194.53,455.98 nfet
M$88 GND_DRV|GND_LOGIC x2_n5 OUT GND_DRV|GND_LOGIC nfet L=0.7U W=10U AS=2.1P
+ AD=2.1P PS=10.42U PD=10.42U
* device instance $89 r0 *1 195.65,455.98 nfet
M$89 OUT x2_n5 GND_DRV|GND_LOGIC GND_DRV|GND_LOGIC nfet L=0.7U W=10U AS=2.1P
+ AD=2.1P PS=10.42U PD=10.42U
* device instance $90 r0 *1 196.77,455.98 nfet
M$90 GND_DRV|GND_LOGIC x2_n5 OUT GND_DRV|GND_LOGIC nfet L=0.7U W=10U AS=2.1P
+ AD=2.1P PS=10.42U PD=10.42U
* device instance $91 r0 *1 197.89,455.98 nfet
M$91 OUT x2_n5 GND_DRV|GND_LOGIC GND_DRV|GND_LOGIC nfet L=0.7U W=10U AS=2.1P
+ AD=2.1P PS=10.42U PD=10.42U
* device instance $92 r0 *1 199.01,455.98 nfet
M$92 GND_DRV|GND_LOGIC x2_n5 OUT GND_DRV|GND_LOGIC nfet L=0.7U W=10U AS=2.1P
+ AD=2.1P PS=10.42U PD=10.42U
* device instance $93 r0 *1 200.13,455.98 nfet
M$93 OUT x2_n5 GND_DRV|GND_LOGIC GND_DRV|GND_LOGIC nfet L=0.7U W=10U AS=2.1P
+ AD=2.1P PS=10.42U PD=10.42U
* device instance $94 r0 *1 201.25,455.98 nfet
M$94 GND_DRV|GND_LOGIC x2_n5 OUT GND_DRV|GND_LOGIC nfet L=0.7U W=10U AS=2.1P
+ AD=2.1P PS=10.42U PD=10.42U
* device instance $95 r0 *1 202.37,455.98 nfet
M$95 OUT x2_n5 GND_DRV|GND_LOGIC GND_DRV|GND_LOGIC nfet L=0.7U W=10U AS=2.1P
+ AD=2.1P PS=10.42U PD=10.42U
* device instance $96 r0 *1 203.49,455.98 nfet
M$96 GND_DRV|GND_LOGIC x2_n5 OUT GND_DRV|GND_LOGIC nfet L=0.7U W=10U AS=2.1P
+ AD=2.1P PS=10.42U PD=10.42U
* device instance $97 r0 *1 204.61,455.98 nfet
M$97 OUT x2_n5 GND_DRV|GND_LOGIC GND_DRV|GND_LOGIC nfet L=0.7U W=10U AS=2.1P
+ AD=2.1P PS=10.42U PD=10.42U
* device instance $98 r0 *1 205.73,455.98 nfet
M$98 GND_DRV|GND_LOGIC x2_n5 OUT GND_DRV|GND_LOGIC nfet L=0.7U W=10U AS=2.1P
+ AD=2.1P PS=10.42U PD=10.42U
* device instance $99 r0 *1 206.85,455.98 nfet
M$99 OUT x2_n5 GND_DRV|GND_LOGIC GND_DRV|GND_LOGIC nfet L=0.7U W=10U AS=2.1P
+ AD=2.1P PS=10.42U PD=10.42U
* device instance $100 r0 *1 207.97,455.98 nfet
M$100 GND_DRV|GND_LOGIC x2_n5 OUT GND_DRV|GND_LOGIC nfet L=0.7U W=10U AS=2.1P
+ AD=2.1P PS=10.42U PD=10.42U
* device instance $101 r0 *1 209.09,455.98 nfet
M$101 OUT x2_n5 GND_DRV|GND_LOGIC GND_DRV|GND_LOGIC nfet L=0.7U W=10U AS=2.1P
+ AD=2.1P PS=10.42U PD=10.42U
* device instance $102 r0 *1 210.21,455.98 nfet
M$102 GND_DRV|GND_LOGIC x2_n5 OUT GND_DRV|GND_LOGIC nfet L=0.7U W=10U AS=2.1P
+ AD=2.1P PS=10.42U PD=10.42U
* device instance $103 r0 *1 211.33,455.98 nfet
M$103 OUT x2_n5 GND_DRV|GND_LOGIC GND_DRV|GND_LOGIC nfet L=0.7U W=10U AS=2.1P
+ AD=2.1P PS=10.42U PD=10.42U
* device instance $104 r0 *1 212.45,455.98 nfet
M$104 GND_DRV|GND_LOGIC x2_n5 OUT GND_DRV|GND_LOGIC nfet L=0.7U W=10U AS=2.1P
+ AD=2.1P PS=10.42U PD=10.42U
* device instance $105 r0 *1 213.57,455.98 nfet
M$105 OUT x2_n5 GND_DRV|GND_LOGIC GND_DRV|GND_LOGIC nfet L=0.7U W=10U AS=2.1P
+ AD=2.1P PS=10.42U PD=10.42U
* device instance $106 r0 *1 214.69,455.98 nfet
M$106 GND_DRV|GND_LOGIC x2_n5 OUT GND_DRV|GND_LOGIC nfet L=0.7U W=10U AS=2.1P
+ AD=2.1P PS=10.42U PD=10.42U
* device instance $107 r0 *1 215.81,455.98 nfet
M$107 OUT x2_n5 GND_DRV|GND_LOGIC GND_DRV|GND_LOGIC nfet L=0.7U W=10U AS=2.1P
+ AD=2.1P PS=10.42U PD=10.42U
* device instance $108 r0 *1 216.93,455.98 nfet
M$108 GND_DRV|GND_LOGIC x2_n5 OUT GND_DRV|GND_LOGIC nfet L=0.7U W=10U AS=2.1P
+ AD=2.1P PS=10.42U PD=10.42U
* device instance $109 r0 *1 218.05,455.98 nfet
M$109 OUT x2_n5 GND_DRV|GND_LOGIC GND_DRV|GND_LOGIC nfet L=0.7U W=10U AS=2.1P
+ AD=2.1P PS=10.42U PD=10.42U
* device instance $110 r0 *1 219.17,455.98 nfet
M$110 GND_DRV|GND_LOGIC x2_n5 OUT GND_DRV|GND_LOGIC nfet L=0.7U W=10U AS=2.1P
+ AD=2.1P PS=10.42U PD=10.42U
* device instance $111 r0 *1 220.29,455.98 nfet
M$111 OUT x2_n5 GND_DRV|GND_LOGIC GND_DRV|GND_LOGIC nfet L=0.7U W=10U AS=2.1P
+ AD=2.1P PS=10.42U PD=10.42U
* device instance $112 r0 *1 221.41,455.98 nfet
M$112 GND_DRV|GND_LOGIC x2_n5 OUT GND_DRV|GND_LOGIC nfet L=0.7U W=10U AS=2.1P
+ AD=2.1P PS=10.42U PD=10.42U
* device instance $113 r0 *1 222.53,455.98 nfet
M$113 OUT x2_n5 GND_DRV|GND_LOGIC GND_DRV|GND_LOGIC nfet L=0.7U W=10U AS=2.1P
+ AD=2.1P PS=10.42U PD=10.42U
* device instance $114 r0 *1 223.65,455.98 nfet
M$114 GND_DRV|GND_LOGIC x2_n5 OUT GND_DRV|GND_LOGIC nfet L=0.7U W=10U AS=2.1P
+ AD=2.1P PS=10.42U PD=10.42U
* device instance $115 r0 *1 224.77,455.98 nfet
M$115 OUT x2_n5 GND_DRV|GND_LOGIC GND_DRV|GND_LOGIC nfet L=0.7U W=10U AS=2.1P
+ AD=2.1P PS=10.42U PD=10.42U
* device instance $116 r0 *1 225.89,455.98 nfet
M$116 GND_DRV|GND_LOGIC x2_n5 OUT GND_DRV|GND_LOGIC nfet L=0.7U W=10U AS=2.1P
+ AD=2.1P PS=10.42U PD=10.42U
* device instance $117 r0 *1 227.01,455.98 nfet
M$117 OUT x2_n5 GND_DRV|GND_LOGIC GND_DRV|GND_LOGIC nfet L=0.7U W=10U AS=2.1P
+ AD=2.1P PS=10.42U PD=10.42U
* device instance $118 r0 *1 228.13,455.98 nfet
M$118 GND_DRV|GND_LOGIC x2_n5 OUT GND_DRV|GND_LOGIC nfet L=0.7U W=10U AS=2.1P
+ AD=2.1P PS=10.42U PD=10.42U
* device instance $119 r0 *1 229.25,455.98 nfet
M$119 OUT x2_n5 GND_DRV|GND_LOGIC GND_DRV|GND_LOGIC nfet L=0.7U W=10U AS=2.1P
+ AD=2.1P PS=10.42U PD=10.42U
* device instance $120 r0 *1 230.37,455.98 nfet
M$120 GND_DRV|GND_LOGIC x2_n5 OUT GND_DRV|GND_LOGIC nfet L=0.7U W=10U AS=2.1P
+ AD=2.1P PS=10.42U PD=10.42U
* device instance $121 r0 *1 231.49,455.98 nfet
M$121 OUT x2_n5 GND_DRV|GND_LOGIC GND_DRV|GND_LOGIC nfet L=0.7U W=10U AS=2.1P
+ AD=2.1P PS=10.42U PD=10.42U
* device instance $122 r0 *1 232.61,455.98 nfet
M$122 GND_DRV|GND_LOGIC x2_n5 OUT GND_DRV|GND_LOGIC nfet L=0.7U W=10U AS=2.1P
+ AD=2.1P PS=10.42U PD=10.42U
* device instance $123 r0 *1 233.73,455.98 nfet
M$123 OUT x2_n5 GND_DRV|GND_LOGIC GND_DRV|GND_LOGIC nfet L=0.7U W=10U AS=2.1P
+ AD=2.1P PS=10.42U PD=10.42U
* device instance $124 r0 *1 234.85,455.98 nfet
M$124 GND_DRV|GND_LOGIC x2_n5 OUT GND_DRV|GND_LOGIC nfet L=0.7U W=10U AS=2.1P
+ AD=2.1P PS=10.42U PD=10.42U
* device instance $125 r0 *1 235.97,455.98 nfet
M$125 OUT x2_n5 GND_DRV|GND_LOGIC GND_DRV|GND_LOGIC nfet L=0.7U W=10U AS=2.1P
+ AD=2.1P PS=10.42U PD=10.42U
* device instance $126 r0 *1 237.09,455.98 nfet
M$126 GND_DRV|GND_LOGIC x2_n5 OUT GND_DRV|GND_LOGIC nfet L=0.7U W=10U AS=2.1P
+ AD=2.1P PS=10.42U PD=10.42U
* device instance $127 r0 *1 238.21,455.98 nfet
M$127 OUT x2_n5 GND_DRV|GND_LOGIC GND_DRV|GND_LOGIC nfet L=0.7U W=10U AS=2.1P
+ AD=2.1P PS=10.42U PD=10.42U
* device instance $128 r0 *1 239.33,455.98 nfet
M$128 GND_DRV|GND_LOGIC x2_n5 OUT GND_DRV|GND_LOGIC nfet L=0.7U W=10U AS=2.1P
+ AD=2.1P PS=10.42U PD=10.42U
* device instance $129 r0 *1 240.45,455.98 nfet
M$129 OUT x2_n5 GND_DRV|GND_LOGIC GND_DRV|GND_LOGIC nfet L=0.7U W=10U AS=2.1P
+ AD=2.1P PS=10.42U PD=10.42U
* device instance $130 r0 *1 241.57,455.98 nfet
M$130 GND_DRV|GND_LOGIC x2_n5 OUT GND_DRV|GND_LOGIC nfet L=0.7U W=10U AS=2.1P
+ AD=2.1P PS=10.42U PD=10.42U
* device instance $131 r0 *1 242.69,455.98 nfet
M$131 OUT x2_n5 GND_DRV|GND_LOGIC GND_DRV|GND_LOGIC nfet L=0.7U W=10U AS=2.1P
+ AD=2.1P PS=10.42U PD=10.42U
* device instance $132 r0 *1 243.81,455.98 nfet
M$132 GND_DRV|GND_LOGIC x2_n5 OUT GND_DRV|GND_LOGIC nfet L=0.7U W=10U AS=2.1P
+ AD=2.1P PS=10.42U PD=10.42U
* device instance $133 r0 *1 244.93,455.98 nfet
M$133 OUT x2_n5 GND_DRV|GND_LOGIC GND_DRV|GND_LOGIC nfet L=0.7U W=10U AS=2.1P
+ AD=2.1P PS=10.42U PD=10.42U
* device instance $134 r0 *1 246.05,455.98 nfet
M$134 GND_DRV|GND_LOGIC x2_n5 OUT GND_DRV|GND_LOGIC nfet L=0.7U W=10U AS=2.1P
+ AD=4.2P PS=10.42U PD=20.84U
* device instance $135 r0 *1 123.97,455.98 nfet
M$135 OUT x2_n5 GND_DRV|GND_LOGIC GND_DRV|GND_LOGIC nfet L=0.7U W=10U AS=2.1P
+ AD=2.1P PS=10.42U PD=10.42U
* device instance $136 r0 *1 125.09,455.98 nfet
M$136 GND_DRV|GND_LOGIC x2_n5 OUT GND_DRV|GND_LOGIC nfet L=0.7U W=10U AS=2.1P
+ AD=2.1P PS=10.42U PD=10.42U
* device instance $137 r0 *1 126.21,455.98 nfet
M$137 OUT x2_n5 GND_DRV|GND_LOGIC GND_DRV|GND_LOGIC nfet L=0.7U W=10U AS=2.1P
+ AD=2.1P PS=10.42U PD=10.42U
* device instance $138 r0 *1 127.33,455.98 nfet
M$138 GND_DRV|GND_LOGIC x2_n5 OUT GND_DRV|GND_LOGIC nfet L=0.7U W=10U AS=2.1P
+ AD=2.1P PS=10.42U PD=10.42U
* device instance $139 r0 *1 128.45,455.98 nfet
M$139 OUT x2_n5 GND_DRV|GND_LOGIC GND_DRV|GND_LOGIC nfet L=0.7U W=10U AS=2.1P
+ AD=2.1P PS=10.42U PD=10.42U
* device instance $140 r0 *1 129.57,455.98 nfet
M$140 GND_DRV|GND_LOGIC x2_n5 OUT GND_DRV|GND_LOGIC nfet L=0.7U W=10U AS=2.1P
+ AD=2.1P PS=10.42U PD=10.42U
* device instance $141 r0 *1 130.69,455.98 nfet
M$141 OUT x2_n5 GND_DRV|GND_LOGIC GND_DRV|GND_LOGIC nfet L=0.7U W=10U AS=2.1P
+ AD=2.1P PS=10.42U PD=10.42U
* device instance $142 r0 *1 131.81,455.98 nfet
M$142 GND_DRV|GND_LOGIC x2_n5 OUT GND_DRV|GND_LOGIC nfet L=0.7U W=10U AS=2.1P
+ AD=2.1P PS=10.42U PD=10.42U
* device instance $143 r0 *1 132.93,455.98 nfet
M$143 OUT x2_n5 GND_DRV|GND_LOGIC GND_DRV|GND_LOGIC nfet L=0.7U W=10U AS=2.1P
+ AD=2.1P PS=10.42U PD=10.42U
* device instance $144 r0 *1 134.05,455.98 nfet
M$144 GND_DRV|GND_LOGIC x2_n5 OUT GND_DRV|GND_LOGIC nfet L=0.7U W=10U AS=2.1P
+ AD=2.1P PS=10.42U PD=10.42U
* device instance $145 r0 *1 135.17,455.98 nfet
M$145 OUT x2_n5 GND_DRV|GND_LOGIC GND_DRV|GND_LOGIC nfet L=0.7U W=10U AS=2.1P
+ AD=2.1P PS=10.42U PD=10.42U
* device instance $146 r0 *1 136.29,455.98 nfet
M$146 GND_DRV|GND_LOGIC x2_n5 OUT GND_DRV|GND_LOGIC nfet L=0.7U W=10U AS=2.1P
+ AD=2.1P PS=10.42U PD=10.42U
* device instance $147 r0 *1 137.41,455.98 nfet
M$147 OUT x2_n5 GND_DRV|GND_LOGIC GND_DRV|GND_LOGIC nfet L=0.7U W=10U AS=2.1P
+ AD=2.1P PS=10.42U PD=10.42U
* device instance $148 r0 *1 138.53,455.98 nfet
M$148 GND_DRV|GND_LOGIC x2_n5 OUT GND_DRV|GND_LOGIC nfet L=0.7U W=10U AS=2.1P
+ AD=2.1P PS=10.42U PD=10.42U
* device instance $149 r0 *1 139.65,455.98 nfet
M$149 OUT x2_n5 GND_DRV|GND_LOGIC GND_DRV|GND_LOGIC nfet L=0.7U W=10U AS=2.1P
+ AD=2.1P PS=10.42U PD=10.42U
* device instance $150 r0 *1 140.77,455.98 nfet
M$150 GND_DRV|GND_LOGIC x2_n5 OUT GND_DRV|GND_LOGIC nfet L=0.7U W=10U AS=2.1P
+ AD=2.1P PS=10.42U PD=10.42U
* device instance $151 r0 *1 141.89,455.98 nfet
M$151 OUT x2_n5 GND_DRV|GND_LOGIC GND_DRV|GND_LOGIC nfet L=0.7U W=10U AS=2.1P
+ AD=2.1P PS=10.42U PD=10.42U
* device instance $152 r0 *1 143.01,455.98 nfet
M$152 GND_DRV|GND_LOGIC x2_n5 OUT GND_DRV|GND_LOGIC nfet L=0.7U W=10U AS=2.1P
+ AD=2.1P PS=10.42U PD=10.42U
* device instance $153 r0 *1 144.13,455.98 nfet
M$153 OUT x2_n5 GND_DRV|GND_LOGIC GND_DRV|GND_LOGIC nfet L=0.7U W=10U AS=2.1P
+ AD=2.1P PS=10.42U PD=10.42U
* device instance $154 r0 *1 145.25,455.98 nfet
M$154 GND_DRV|GND_LOGIC x2_n5 OUT GND_DRV|GND_LOGIC nfet L=0.7U W=10U AS=2.1P
+ AD=2.1P PS=10.42U PD=10.42U
* device instance $155 r0 *1 146.37,455.98 nfet
M$155 OUT x2_n5 GND_DRV|GND_LOGIC GND_DRV|GND_LOGIC nfet L=0.7U W=10U AS=2.1P
+ AD=2.1P PS=10.42U PD=10.42U
* device instance $156 r0 *1 147.49,455.98 nfet
M$156 GND_DRV|GND_LOGIC x2_n5 OUT GND_DRV|GND_LOGIC nfet L=0.7U W=10U AS=2.1P
+ AD=2.1P PS=10.42U PD=10.42U
* device instance $157 r0 *1 148.61,455.98 nfet
M$157 OUT x2_n5 GND_DRV|GND_LOGIC GND_DRV|GND_LOGIC nfet L=0.7U W=10U AS=2.1P
+ AD=2.1P PS=10.42U PD=10.42U
* device instance $158 r0 *1 149.73,455.98 nfet
M$158 GND_DRV|GND_LOGIC x2_n5 OUT GND_DRV|GND_LOGIC nfet L=0.7U W=10U AS=2.1P
+ AD=2.1P PS=10.42U PD=10.42U
* device instance $159 r0 *1 150.85,455.98 nfet
M$159 OUT x2_n5 GND_DRV|GND_LOGIC GND_DRV|GND_LOGIC nfet L=0.7U W=10U AS=2.1P
+ AD=2.1P PS=10.42U PD=10.42U
* device instance $160 r0 *1 151.97,455.98 nfet
M$160 GND_DRV|GND_LOGIC x2_n5 OUT GND_DRV|GND_LOGIC nfet L=0.7U W=10U AS=2.1P
+ AD=2.1P PS=10.42U PD=10.42U
* device instance $161 r0 *1 153.09,455.98 nfet
M$161 OUT x2_n5 GND_DRV|GND_LOGIC GND_DRV|GND_LOGIC nfet L=0.7U W=10U AS=2.1P
+ AD=2.1P PS=10.42U PD=10.42U
* device instance $162 r0 *1 154.21,455.98 nfet
M$162 GND_DRV|GND_LOGIC x2_n5 OUT GND_DRV|GND_LOGIC nfet L=0.7U W=10U AS=2.1P
+ AD=2.1P PS=10.42U PD=10.42U
* device instance $163 r0 *1 155.33,455.98 nfet
M$163 OUT x2_n5 GND_DRV|GND_LOGIC GND_DRV|GND_LOGIC nfet L=0.7U W=10U AS=2.1P
+ AD=2.1P PS=10.42U PD=10.42U
* device instance $164 r0 *1 156.45,455.98 nfet
M$164 GND_DRV|GND_LOGIC x2_n5 OUT GND_DRV|GND_LOGIC nfet L=0.7U W=10U AS=2.1P
+ AD=2.1P PS=10.42U PD=10.42U
* device instance $165 r0 *1 157.57,455.98 nfet
M$165 OUT x2_n5 GND_DRV|GND_LOGIC GND_DRV|GND_LOGIC nfet L=0.7U W=10U AS=2.1P
+ AD=2.1P PS=10.42U PD=10.42U
* device instance $166 r0 *1 158.69,455.98 nfet
M$166 GND_DRV|GND_LOGIC x2_n5 OUT GND_DRV|GND_LOGIC nfet L=0.7U W=10U AS=2.1P
+ AD=2.1P PS=10.42U PD=10.42U
* device instance $167 r0 *1 159.81,455.98 nfet
M$167 OUT x2_n5 GND_DRV|GND_LOGIC GND_DRV|GND_LOGIC nfet L=0.7U W=10U AS=2.1P
+ AD=2.1P PS=10.42U PD=10.42U
* device instance $168 r0 *1 160.93,455.98 nfet
M$168 GND_DRV|GND_LOGIC x2_n5 OUT GND_DRV|GND_LOGIC nfet L=0.7U W=10U AS=2.1P
+ AD=2.1P PS=10.42U PD=10.42U
* device instance $169 r0 *1 162.05,455.98 nfet
M$169 OUT x2_n5 GND_DRV|GND_LOGIC GND_DRV|GND_LOGIC nfet L=0.7U W=10U AS=2.1P
+ AD=2.1P PS=10.42U PD=10.42U
* device instance $170 r0 *1 163.17,455.98 nfet
M$170 GND_DRV|GND_LOGIC x2_n5 OUT GND_DRV|GND_LOGIC nfet L=0.7U W=10U AS=2.1P
+ AD=2.1P PS=10.42U PD=10.42U
* device instance $171 r0 *1 164.29,455.98 nfet
M$171 OUT x2_n5 GND_DRV|GND_LOGIC GND_DRV|GND_LOGIC nfet L=0.7U W=10U AS=2.1P
+ AD=2.1P PS=10.42U PD=10.42U
* device instance $172 r0 *1 165.41,455.98 nfet
M$172 GND_DRV|GND_LOGIC x2_n5 OUT GND_DRV|GND_LOGIC nfet L=0.7U W=10U AS=2.1P
+ AD=2.1P PS=10.42U PD=10.42U
* device instance $173 r0 *1 166.53,455.98 nfet
M$173 OUT x2_n5 GND_DRV|GND_LOGIC GND_DRV|GND_LOGIC nfet L=0.7U W=10U AS=2.1P
+ AD=2.1P PS=10.42U PD=10.42U
* device instance $174 r0 *1 167.65,455.98 nfet
M$174 GND_DRV|GND_LOGIC x2_n5 OUT GND_DRV|GND_LOGIC nfet L=0.7U W=10U AS=2.1P
+ AD=2.1P PS=10.42U PD=10.42U
* device instance $175 r0 *1 168.77,455.98 nfet
M$175 OUT x2_n5 GND_DRV|GND_LOGIC GND_DRV|GND_LOGIC nfet L=0.7U W=10U AS=2.1P
+ AD=2.1P PS=10.42U PD=10.42U
* device instance $176 r0 *1 169.89,455.98 nfet
M$176 GND_DRV|GND_LOGIC x2_n5 OUT GND_DRV|GND_LOGIC nfet L=0.7U W=10U AS=2.1P
+ AD=2.1P PS=10.42U PD=10.42U
* device instance $177 r0 *1 171.01,455.98 nfet
M$177 OUT x2_n5 GND_DRV|GND_LOGIC GND_DRV|GND_LOGIC nfet L=0.7U W=10U AS=2.1P
+ AD=2.1P PS=10.42U PD=10.42U
* device instance $178 r0 *1 172.13,455.98 nfet
M$178 GND_DRV|GND_LOGIC x2_n5 OUT GND_DRV|GND_LOGIC nfet L=0.7U W=10U AS=2.1P
+ AD=2.1P PS=10.42U PD=10.42U
* device instance $179 r0 *1 173.25,455.98 nfet
M$179 OUT x2_n5 GND_DRV|GND_LOGIC GND_DRV|GND_LOGIC nfet L=0.7U W=10U AS=2.1P
+ AD=2.1P PS=10.42U PD=10.42U
* device instance $180 r0 *1 174.37,455.98 nfet
M$180 GND_DRV|GND_LOGIC x2_n5 OUT GND_DRV|GND_LOGIC nfet L=0.7U W=10U AS=2.1P
+ AD=2.1P PS=10.42U PD=10.42U
* device instance $181 r0 *1 175.49,455.98 nfet
M$181 OUT x2_n5 GND_DRV|GND_LOGIC GND_DRV|GND_LOGIC nfet L=0.7U W=10U AS=2.1P
+ AD=2.1P PS=10.42U PD=10.42U
* device instance $182 r0 *1 176.61,455.98 nfet
M$182 GND_DRV|GND_LOGIC x2_n5 OUT GND_DRV|GND_LOGIC nfet L=0.7U W=10U AS=2.1P
+ AD=2.1P PS=10.42U PD=10.42U
* device instance $183 r0 *1 177.73,455.98 nfet
M$183 OUT x2_n5 GND_DRV|GND_LOGIC GND_DRV|GND_LOGIC nfet L=0.7U W=10U AS=2.1P
+ AD=2.1P PS=10.42U PD=10.42U
* device instance $184 r0 *1 178.85,455.98 nfet
M$184 GND_DRV|GND_LOGIC x2_n5 OUT GND_DRV|GND_LOGIC nfet L=0.7U W=10U AS=2.1P
+ AD=2.1P PS=10.42U PD=10.42U
* device instance $185 r0 *1 179.97,455.98 nfet
M$185 OUT x2_n5 GND_DRV|GND_LOGIC GND_DRV|GND_LOGIC nfet L=0.7U W=10U AS=2.1P
+ AD=2.1P PS=10.42U PD=10.42U
* device instance $186 r0 *1 181.09,455.98 nfet
M$186 GND_DRV|GND_LOGIC x2_n5 OUT GND_DRV|GND_LOGIC nfet L=0.7U W=10U AS=2.1P
+ AD=2.1P PS=10.42U PD=10.42U
* device instance $187 r0 *1 182.21,455.98 nfet
M$187 OUT x2_n5 GND_DRV|GND_LOGIC GND_DRV|GND_LOGIC nfet L=0.7U W=10U AS=2.1P
+ AD=2.1P PS=10.42U PD=10.42U
* device instance $188 r0 *1 183.33,455.98 nfet
M$188 GND_DRV|GND_LOGIC x2_n5 OUT GND_DRV|GND_LOGIC nfet L=0.7U W=10U AS=2.1P
+ AD=2.1P PS=10.42U PD=10.42U
* device instance $189 r0 *1 184.45,455.98 nfet
M$189 OUT x2_n5 GND_DRV|GND_LOGIC GND_DRV|GND_LOGIC nfet L=0.7U W=10U AS=2.1P
+ AD=2.1P PS=10.42U PD=10.42U
* device instance $190 r0 *1 62.37,455.98 nfet
M$190 GND_DRV|GND_LOGIC x2_n5 OUT GND_DRV|GND_LOGIC nfet L=0.7U W=10U AS=2.1P
+ AD=2.1P PS=10.42U PD=10.42U
* device instance $191 r0 *1 63.49,455.98 nfet
M$191 OUT x2_n5 GND_DRV|GND_LOGIC GND_DRV|GND_LOGIC nfet L=0.7U W=10U AS=2.1P
+ AD=2.1P PS=10.42U PD=10.42U
* device instance $192 r0 *1 64.61,455.98 nfet
M$192 GND_DRV|GND_LOGIC x2_n5 OUT GND_DRV|GND_LOGIC nfet L=0.7U W=10U AS=2.1P
+ AD=2.1P PS=10.42U PD=10.42U
* device instance $193 r0 *1 65.73,455.98 nfet
M$193 OUT x2_n5 GND_DRV|GND_LOGIC GND_DRV|GND_LOGIC nfet L=0.7U W=10U AS=2.1P
+ AD=2.1P PS=10.42U PD=10.42U
* device instance $194 r0 *1 66.85,455.98 nfet
M$194 GND_DRV|GND_LOGIC x2_n5 OUT GND_DRV|GND_LOGIC nfet L=0.7U W=10U AS=2.1P
+ AD=2.1P PS=10.42U PD=10.42U
* device instance $195 r0 *1 67.97,455.98 nfet
M$195 OUT x2_n5 GND_DRV|GND_LOGIC GND_DRV|GND_LOGIC nfet L=0.7U W=10U AS=2.1P
+ AD=2.1P PS=10.42U PD=10.42U
* device instance $196 r0 *1 69.09,455.98 nfet
M$196 GND_DRV|GND_LOGIC x2_n5 OUT GND_DRV|GND_LOGIC nfet L=0.7U W=10U AS=2.1P
+ AD=2.1P PS=10.42U PD=10.42U
* device instance $197 r0 *1 70.21,455.98 nfet
M$197 OUT x2_n5 GND_DRV|GND_LOGIC GND_DRV|GND_LOGIC nfet L=0.7U W=10U AS=2.1P
+ AD=2.1P PS=10.42U PD=10.42U
* device instance $198 r0 *1 71.33,455.98 nfet
M$198 GND_DRV|GND_LOGIC x2_n5 OUT GND_DRV|GND_LOGIC nfet L=0.7U W=10U AS=2.1P
+ AD=2.1P PS=10.42U PD=10.42U
* device instance $199 r0 *1 72.45,455.98 nfet
M$199 OUT x2_n5 GND_DRV|GND_LOGIC GND_DRV|GND_LOGIC nfet L=0.7U W=10U AS=2.1P
+ AD=2.1P PS=10.42U PD=10.42U
* device instance $200 r0 *1 73.57,455.98 nfet
M$200 GND_DRV|GND_LOGIC x2_n5 OUT GND_DRV|GND_LOGIC nfet L=0.7U W=10U AS=2.1P
+ AD=2.1P PS=10.42U PD=10.42U
* device instance $201 r0 *1 74.69,455.98 nfet
M$201 OUT x2_n5 GND_DRV|GND_LOGIC GND_DRV|GND_LOGIC nfet L=0.7U W=10U AS=2.1P
+ AD=2.1P PS=10.42U PD=10.42U
* device instance $202 r0 *1 75.81,455.98 nfet
M$202 GND_DRV|GND_LOGIC x2_n5 OUT GND_DRV|GND_LOGIC nfet L=0.7U W=10U AS=2.1P
+ AD=2.1P PS=10.42U PD=10.42U
* device instance $203 r0 *1 76.93,455.98 nfet
M$203 OUT x2_n5 GND_DRV|GND_LOGIC GND_DRV|GND_LOGIC nfet L=0.7U W=10U AS=2.1P
+ AD=2.1P PS=10.42U PD=10.42U
* device instance $204 r0 *1 78.05,455.98 nfet
M$204 GND_DRV|GND_LOGIC x2_n5 OUT GND_DRV|GND_LOGIC nfet L=0.7U W=10U AS=2.1P
+ AD=2.1P PS=10.42U PD=10.42U
* device instance $205 r0 *1 79.17,455.98 nfet
M$205 OUT x2_n5 GND_DRV|GND_LOGIC GND_DRV|GND_LOGIC nfet L=0.7U W=10U AS=2.1P
+ AD=2.1P PS=10.42U PD=10.42U
* device instance $206 r0 *1 80.29,455.98 nfet
M$206 GND_DRV|GND_LOGIC x2_n5 OUT GND_DRV|GND_LOGIC nfet L=0.7U W=10U AS=2.1P
+ AD=2.1P PS=10.42U PD=10.42U
* device instance $207 r0 *1 81.41,455.98 nfet
M$207 OUT x2_n5 GND_DRV|GND_LOGIC GND_DRV|GND_LOGIC nfet L=0.7U W=10U AS=2.1P
+ AD=2.1P PS=10.42U PD=10.42U
* device instance $208 r0 *1 82.53,455.98 nfet
M$208 GND_DRV|GND_LOGIC x2_n5 OUT GND_DRV|GND_LOGIC nfet L=0.7U W=10U AS=2.1P
+ AD=2.1P PS=10.42U PD=10.42U
* device instance $209 r0 *1 83.65,455.98 nfet
M$209 OUT x2_n5 GND_DRV|GND_LOGIC GND_DRV|GND_LOGIC nfet L=0.7U W=10U AS=2.1P
+ AD=2.1P PS=10.42U PD=10.42U
* device instance $210 r0 *1 84.77,455.98 nfet
M$210 GND_DRV|GND_LOGIC x2_n5 OUT GND_DRV|GND_LOGIC nfet L=0.7U W=10U AS=2.1P
+ AD=2.1P PS=10.42U PD=10.42U
* device instance $211 r0 *1 85.89,455.98 nfet
M$211 OUT x2_n5 GND_DRV|GND_LOGIC GND_DRV|GND_LOGIC nfet L=0.7U W=10U AS=2.1P
+ AD=2.1P PS=10.42U PD=10.42U
* device instance $212 r0 *1 87.01,455.98 nfet
M$212 GND_DRV|GND_LOGIC x2_n5 OUT GND_DRV|GND_LOGIC nfet L=0.7U W=10U AS=2.1P
+ AD=2.1P PS=10.42U PD=10.42U
* device instance $213 r0 *1 88.13,455.98 nfet
M$213 OUT x2_n5 GND_DRV|GND_LOGIC GND_DRV|GND_LOGIC nfet L=0.7U W=10U AS=2.1P
+ AD=2.1P PS=10.42U PD=10.42U
* device instance $214 r0 *1 89.25,455.98 nfet
M$214 GND_DRV|GND_LOGIC x2_n5 OUT GND_DRV|GND_LOGIC nfet L=0.7U W=10U AS=2.1P
+ AD=2.1P PS=10.42U PD=10.42U
* device instance $215 r0 *1 90.37,455.98 nfet
M$215 OUT x2_n5 GND_DRV|GND_LOGIC GND_DRV|GND_LOGIC nfet L=0.7U W=10U AS=2.1P
+ AD=2.1P PS=10.42U PD=10.42U
* device instance $216 r0 *1 91.49,455.98 nfet
M$216 GND_DRV|GND_LOGIC x2_n5 OUT GND_DRV|GND_LOGIC nfet L=0.7U W=10U AS=2.1P
+ AD=2.1P PS=10.42U PD=10.42U
* device instance $217 r0 *1 92.61,455.98 nfet
M$217 OUT x2_n5 GND_DRV|GND_LOGIC GND_DRV|GND_LOGIC nfet L=0.7U W=10U AS=2.1P
+ AD=2.1P PS=10.42U PD=10.42U
* device instance $218 r0 *1 93.73,455.98 nfet
M$218 GND_DRV|GND_LOGIC x2_n5 OUT GND_DRV|GND_LOGIC nfet L=0.7U W=10U AS=2.1P
+ AD=2.1P PS=10.42U PD=10.42U
* device instance $219 r0 *1 94.85,455.98 nfet
M$219 OUT x2_n5 GND_DRV|GND_LOGIC GND_DRV|GND_LOGIC nfet L=0.7U W=10U AS=2.1P
+ AD=2.1P PS=10.42U PD=10.42U
* device instance $220 r0 *1 95.97,455.98 nfet
M$220 GND_DRV|GND_LOGIC x2_n5 OUT GND_DRV|GND_LOGIC nfet L=0.7U W=10U AS=2.1P
+ AD=2.1P PS=10.42U PD=10.42U
* device instance $221 r0 *1 97.09,455.98 nfet
M$221 OUT x2_n5 GND_DRV|GND_LOGIC GND_DRV|GND_LOGIC nfet L=0.7U W=10U AS=2.1P
+ AD=2.1P PS=10.42U PD=10.42U
* device instance $222 r0 *1 98.21,455.98 nfet
M$222 GND_DRV|GND_LOGIC x2_n5 OUT GND_DRV|GND_LOGIC nfet L=0.7U W=10U AS=2.1P
+ AD=2.1P PS=10.42U PD=10.42U
* device instance $223 r0 *1 99.33,455.98 nfet
M$223 OUT x2_n5 GND_DRV|GND_LOGIC GND_DRV|GND_LOGIC nfet L=0.7U W=10U AS=2.1P
+ AD=2.1P PS=10.42U PD=10.42U
* device instance $224 r0 *1 100.45,455.98 nfet
M$224 GND_DRV|GND_LOGIC x2_n5 OUT GND_DRV|GND_LOGIC nfet L=0.7U W=10U AS=2.1P
+ AD=2.1P PS=10.42U PD=10.42U
* device instance $225 r0 *1 101.57,455.98 nfet
M$225 OUT x2_n5 GND_DRV|GND_LOGIC GND_DRV|GND_LOGIC nfet L=0.7U W=10U AS=2.1P
+ AD=2.1P PS=10.42U PD=10.42U
* device instance $226 r0 *1 102.69,455.98 nfet
M$226 GND_DRV|GND_LOGIC x2_n5 OUT GND_DRV|GND_LOGIC nfet L=0.7U W=10U AS=2.1P
+ AD=2.1P PS=10.42U PD=10.42U
* device instance $227 r0 *1 103.81,455.98 nfet
M$227 OUT x2_n5 GND_DRV|GND_LOGIC GND_DRV|GND_LOGIC nfet L=0.7U W=10U AS=2.1P
+ AD=2.1P PS=10.42U PD=10.42U
* device instance $228 r0 *1 104.93,455.98 nfet
M$228 GND_DRV|GND_LOGIC x2_n5 OUT GND_DRV|GND_LOGIC nfet L=0.7U W=10U AS=2.1P
+ AD=2.1P PS=10.42U PD=10.42U
* device instance $229 r0 *1 106.05,455.98 nfet
M$229 OUT x2_n5 GND_DRV|GND_LOGIC GND_DRV|GND_LOGIC nfet L=0.7U W=10U AS=2.1P
+ AD=2.1P PS=10.42U PD=10.42U
* device instance $230 r0 *1 107.17,455.98 nfet
M$230 GND_DRV|GND_LOGIC x2_n5 OUT GND_DRV|GND_LOGIC nfet L=0.7U W=10U AS=2.1P
+ AD=2.1P PS=10.42U PD=10.42U
* device instance $231 r0 *1 108.29,455.98 nfet
M$231 OUT x2_n5 GND_DRV|GND_LOGIC GND_DRV|GND_LOGIC nfet L=0.7U W=10U AS=2.1P
+ AD=2.1P PS=10.42U PD=10.42U
* device instance $232 r0 *1 109.41,455.98 nfet
M$232 GND_DRV|GND_LOGIC x2_n5 OUT GND_DRV|GND_LOGIC nfet L=0.7U W=10U AS=2.1P
+ AD=2.1P PS=10.42U PD=10.42U
* device instance $233 r0 *1 110.53,455.98 nfet
M$233 OUT x2_n5 GND_DRV|GND_LOGIC GND_DRV|GND_LOGIC nfet L=0.7U W=10U AS=2.1P
+ AD=2.1P PS=10.42U PD=10.42U
* device instance $234 r0 *1 111.65,455.98 nfet
M$234 GND_DRV|GND_LOGIC x2_n5 OUT GND_DRV|GND_LOGIC nfet L=0.7U W=10U AS=2.1P
+ AD=2.1P PS=10.42U PD=10.42U
* device instance $235 r0 *1 112.77,455.98 nfet
M$235 OUT x2_n5 GND_DRV|GND_LOGIC GND_DRV|GND_LOGIC nfet L=0.7U W=10U AS=2.1P
+ AD=2.1P PS=10.42U PD=10.42U
* device instance $236 r0 *1 113.89,455.98 nfet
M$236 GND_DRV|GND_LOGIC x2_n5 OUT GND_DRV|GND_LOGIC nfet L=0.7U W=10U AS=2.1P
+ AD=2.1P PS=10.42U PD=10.42U
* device instance $237 r0 *1 115.01,455.98 nfet
M$237 OUT x2_n5 GND_DRV|GND_LOGIC GND_DRV|GND_LOGIC nfet L=0.7U W=10U AS=2.1P
+ AD=2.1P PS=10.42U PD=10.42U
* device instance $238 r0 *1 116.13,455.98 nfet
M$238 GND_DRV|GND_LOGIC x2_n5 OUT GND_DRV|GND_LOGIC nfet L=0.7U W=10U AS=2.1P
+ AD=2.1P PS=10.42U PD=10.42U
* device instance $239 r0 *1 117.25,455.98 nfet
M$239 OUT x2_n5 GND_DRV|GND_LOGIC GND_DRV|GND_LOGIC nfet L=0.7U W=10U AS=2.1P
+ AD=2.1P PS=10.42U PD=10.42U
* device instance $240 r0 *1 118.37,455.98 nfet
M$240 GND_DRV|GND_LOGIC x2_n5 OUT GND_DRV|GND_LOGIC nfet L=0.7U W=10U AS=2.1P
+ AD=2.1P PS=10.42U PD=10.42U
* device instance $241 r0 *1 119.49,455.98 nfet
M$241 OUT x2_n5 GND_DRV|GND_LOGIC GND_DRV|GND_LOGIC nfet L=0.7U W=10U AS=2.1P
+ AD=2.1P PS=10.42U PD=10.42U
* device instance $242 r0 *1 120.61,455.98 nfet
M$242 GND_DRV|GND_LOGIC x2_n5 OUT GND_DRV|GND_LOGIC nfet L=0.7U W=10U AS=2.1P
+ AD=2.1P PS=10.42U PD=10.42U
* device instance $243 r0 *1 121.73,455.98 nfet
M$243 OUT x2_n5 GND_DRV|GND_LOGIC GND_DRV|GND_LOGIC nfet L=0.7U W=10U AS=2.1P
+ AD=2.1P PS=10.42U PD=10.42U
* device instance $244 r0 *1 122.85,455.98 nfet
M$244 GND_DRV|GND_LOGIC x2_n5 OUT GND_DRV|GND_LOGIC nfet L=0.7U W=10U AS=2.1P
+ AD=2.1P PS=10.42U PD=10.42U
* device instance $245 r0 *1 0.77,455.98 nfet
M$245 OUT x2_n5 GND_DRV|GND_LOGIC GND_DRV|GND_LOGIC nfet L=0.7U W=10U AS=4.2P
+ AD=2.1P PS=20.84U PD=10.42U
* device instance $246 r0 *1 1.89,455.98 nfet
M$246 GND_DRV|GND_LOGIC x2_n5 OUT GND_DRV|GND_LOGIC nfet L=0.7U W=10U AS=2.1P
+ AD=2.1P PS=10.42U PD=10.42U
* device instance $247 r0 *1 3.01,455.98 nfet
M$247 OUT x2_n5 GND_DRV|GND_LOGIC GND_DRV|GND_LOGIC nfet L=0.7U W=10U AS=2.1P
+ AD=2.1P PS=10.42U PD=10.42U
* device instance $248 r0 *1 4.13,455.98 nfet
M$248 GND_DRV|GND_LOGIC x2_n5 OUT GND_DRV|GND_LOGIC nfet L=0.7U W=10U AS=2.1P
+ AD=2.1P PS=10.42U PD=10.42U
* device instance $249 r0 *1 5.25,455.98 nfet
M$249 OUT x2_n5 GND_DRV|GND_LOGIC GND_DRV|GND_LOGIC nfet L=0.7U W=10U AS=2.1P
+ AD=2.1P PS=10.42U PD=10.42U
* device instance $250 r0 *1 6.37,455.98 nfet
M$250 GND_DRV|GND_LOGIC x2_n5 OUT GND_DRV|GND_LOGIC nfet L=0.7U W=10U AS=2.1P
+ AD=2.1P PS=10.42U PD=10.42U
* device instance $251 r0 *1 7.49,455.98 nfet
M$251 OUT x2_n5 GND_DRV|GND_LOGIC GND_DRV|GND_LOGIC nfet L=0.7U W=10U AS=2.1P
+ AD=2.1P PS=10.42U PD=10.42U
* device instance $252 r0 *1 8.61,455.98 nfet
M$252 GND_DRV|GND_LOGIC x2_n5 OUT GND_DRV|GND_LOGIC nfet L=0.7U W=10U AS=2.1P
+ AD=2.1P PS=10.42U PD=10.42U
* device instance $253 r0 *1 9.73,455.98 nfet
M$253 OUT x2_n5 GND_DRV|GND_LOGIC GND_DRV|GND_LOGIC nfet L=0.7U W=10U AS=2.1P
+ AD=2.1P PS=10.42U PD=10.42U
* device instance $254 r0 *1 10.85,455.98 nfet
M$254 GND_DRV|GND_LOGIC x2_n5 OUT GND_DRV|GND_LOGIC nfet L=0.7U W=10U AS=2.1P
+ AD=2.1P PS=10.42U PD=10.42U
* device instance $255 r0 *1 11.97,455.98 nfet
M$255 OUT x2_n5 GND_DRV|GND_LOGIC GND_DRV|GND_LOGIC nfet L=0.7U W=10U AS=2.1P
+ AD=2.1P PS=10.42U PD=10.42U
* device instance $256 r0 *1 13.09,455.98 nfet
M$256 GND_DRV|GND_LOGIC x2_n5 OUT GND_DRV|GND_LOGIC nfet L=0.7U W=10U AS=2.1P
+ AD=2.1P PS=10.42U PD=10.42U
* device instance $257 r0 *1 14.21,455.98 nfet
M$257 OUT x2_n5 GND_DRV|GND_LOGIC GND_DRV|GND_LOGIC nfet L=0.7U W=10U AS=2.1P
+ AD=2.1P PS=10.42U PD=10.42U
* device instance $258 r0 *1 15.33,455.98 nfet
M$258 GND_DRV|GND_LOGIC x2_n5 OUT GND_DRV|GND_LOGIC nfet L=0.7U W=10U AS=2.1P
+ AD=2.1P PS=10.42U PD=10.42U
* device instance $259 r0 *1 16.45,455.98 nfet
M$259 OUT x2_n5 GND_DRV|GND_LOGIC GND_DRV|GND_LOGIC nfet L=0.7U W=10U AS=2.1P
+ AD=2.1P PS=10.42U PD=10.42U
* device instance $260 r0 *1 17.57,455.98 nfet
M$260 GND_DRV|GND_LOGIC x2_n5 OUT GND_DRV|GND_LOGIC nfet L=0.7U W=10U AS=2.1P
+ AD=2.1P PS=10.42U PD=10.42U
* device instance $261 r0 *1 18.69,455.98 nfet
M$261 OUT x2_n5 GND_DRV|GND_LOGIC GND_DRV|GND_LOGIC nfet L=0.7U W=10U AS=2.1P
+ AD=2.1P PS=10.42U PD=10.42U
* device instance $262 r0 *1 19.81,455.98 nfet
M$262 GND_DRV|GND_LOGIC x2_n5 OUT GND_DRV|GND_LOGIC nfet L=0.7U W=10U AS=2.1P
+ AD=2.1P PS=10.42U PD=10.42U
* device instance $263 r0 *1 20.93,455.98 nfet
M$263 OUT x2_n5 GND_DRV|GND_LOGIC GND_DRV|GND_LOGIC nfet L=0.7U W=10U AS=2.1P
+ AD=2.1P PS=10.42U PD=10.42U
* device instance $264 r0 *1 22.05,455.98 nfet
M$264 GND_DRV|GND_LOGIC x2_n5 OUT GND_DRV|GND_LOGIC nfet L=0.7U W=10U AS=2.1P
+ AD=2.1P PS=10.42U PD=10.42U
* device instance $265 r0 *1 23.17,455.98 nfet
M$265 OUT x2_n5 GND_DRV|GND_LOGIC GND_DRV|GND_LOGIC nfet L=0.7U W=10U AS=2.1P
+ AD=2.1P PS=10.42U PD=10.42U
* device instance $266 r0 *1 24.29,455.98 nfet
M$266 GND_DRV|GND_LOGIC x2_n5 OUT GND_DRV|GND_LOGIC nfet L=0.7U W=10U AS=2.1P
+ AD=2.1P PS=10.42U PD=10.42U
* device instance $267 r0 *1 25.41,455.98 nfet
M$267 OUT x2_n5 GND_DRV|GND_LOGIC GND_DRV|GND_LOGIC nfet L=0.7U W=10U AS=2.1P
+ AD=2.1P PS=10.42U PD=10.42U
* device instance $268 r0 *1 26.53,455.98 nfet
M$268 GND_DRV|GND_LOGIC x2_n5 OUT GND_DRV|GND_LOGIC nfet L=0.7U W=10U AS=2.1P
+ AD=2.1P PS=10.42U PD=10.42U
* device instance $269 r0 *1 27.65,455.98 nfet
M$269 OUT x2_n5 GND_DRV|GND_LOGIC GND_DRV|GND_LOGIC nfet L=0.7U W=10U AS=2.1P
+ AD=2.1P PS=10.42U PD=10.42U
* device instance $270 r0 *1 28.77,455.98 nfet
M$270 GND_DRV|GND_LOGIC x2_n5 OUT GND_DRV|GND_LOGIC nfet L=0.7U W=10U AS=2.1P
+ AD=2.1P PS=10.42U PD=10.42U
* device instance $271 r0 *1 29.89,455.98 nfet
M$271 OUT x2_n5 GND_DRV|GND_LOGIC GND_DRV|GND_LOGIC nfet L=0.7U W=10U AS=2.1P
+ AD=2.1P PS=10.42U PD=10.42U
* device instance $272 r0 *1 31.01,455.98 nfet
M$272 GND_DRV|GND_LOGIC x2_n5 OUT GND_DRV|GND_LOGIC nfet L=0.7U W=10U AS=2.1P
+ AD=2.1P PS=10.42U PD=10.42U
* device instance $273 r0 *1 32.13,455.98 nfet
M$273 OUT x2_n5 GND_DRV|GND_LOGIC GND_DRV|GND_LOGIC nfet L=0.7U W=10U AS=2.1P
+ AD=2.1P PS=10.42U PD=10.42U
* device instance $274 r0 *1 33.25,455.98 nfet
M$274 GND_DRV|GND_LOGIC x2_n5 OUT GND_DRV|GND_LOGIC nfet L=0.7U W=10U AS=2.1P
+ AD=2.1P PS=10.42U PD=10.42U
* device instance $275 r0 *1 34.37,455.98 nfet
M$275 OUT x2_n5 GND_DRV|GND_LOGIC GND_DRV|GND_LOGIC nfet L=0.7U W=10U AS=2.1P
+ AD=2.1P PS=10.42U PD=10.42U
* device instance $276 r0 *1 35.49,455.98 nfet
M$276 GND_DRV|GND_LOGIC x2_n5 OUT GND_DRV|GND_LOGIC nfet L=0.7U W=10U AS=2.1P
+ AD=2.1P PS=10.42U PD=10.42U
* device instance $277 r0 *1 36.61,455.98 nfet
M$277 OUT x2_n5 GND_DRV|GND_LOGIC GND_DRV|GND_LOGIC nfet L=0.7U W=10U AS=2.1P
+ AD=2.1P PS=10.42U PD=10.42U
* device instance $278 r0 *1 37.73,455.98 nfet
M$278 GND_DRV|GND_LOGIC x2_n5 OUT GND_DRV|GND_LOGIC nfet L=0.7U W=10U AS=2.1P
+ AD=2.1P PS=10.42U PD=10.42U
* device instance $279 r0 *1 38.85,455.98 nfet
M$279 OUT x2_n5 GND_DRV|GND_LOGIC GND_DRV|GND_LOGIC nfet L=0.7U W=10U AS=2.1P
+ AD=2.1P PS=10.42U PD=10.42U
* device instance $280 r0 *1 39.97,455.98 nfet
M$280 GND_DRV|GND_LOGIC x2_n5 OUT GND_DRV|GND_LOGIC nfet L=0.7U W=10U AS=2.1P
+ AD=2.1P PS=10.42U PD=10.42U
* device instance $281 r0 *1 41.09,455.98 nfet
M$281 OUT x2_n5 GND_DRV|GND_LOGIC GND_DRV|GND_LOGIC nfet L=0.7U W=10U AS=2.1P
+ AD=2.1P PS=10.42U PD=10.42U
* device instance $282 r0 *1 42.21,455.98 nfet
M$282 GND_DRV|GND_LOGIC x2_n5 OUT GND_DRV|GND_LOGIC nfet L=0.7U W=10U AS=2.1P
+ AD=2.1P PS=10.42U PD=10.42U
* device instance $283 r0 *1 43.33,455.98 nfet
M$283 OUT x2_n5 GND_DRV|GND_LOGIC GND_DRV|GND_LOGIC nfet L=0.7U W=10U AS=2.1P
+ AD=2.1P PS=10.42U PD=10.42U
* device instance $284 r0 *1 44.45,455.98 nfet
M$284 GND_DRV|GND_LOGIC x2_n5 OUT GND_DRV|GND_LOGIC nfet L=0.7U W=10U AS=2.1P
+ AD=2.1P PS=10.42U PD=10.42U
* device instance $285 r0 *1 45.57,455.98 nfet
M$285 OUT x2_n5 GND_DRV|GND_LOGIC GND_DRV|GND_LOGIC nfet L=0.7U W=10U AS=2.1P
+ AD=2.1P PS=10.42U PD=10.42U
* device instance $286 r0 *1 46.69,455.98 nfet
M$286 GND_DRV|GND_LOGIC x2_n5 OUT GND_DRV|GND_LOGIC nfet L=0.7U W=10U AS=2.1P
+ AD=2.1P PS=10.42U PD=10.42U
* device instance $287 r0 *1 47.81,455.98 nfet
M$287 OUT x2_n5 GND_DRV|GND_LOGIC GND_DRV|GND_LOGIC nfet L=0.7U W=10U AS=2.1P
+ AD=2.1P PS=10.42U PD=10.42U
* device instance $288 r0 *1 48.93,455.98 nfet
M$288 GND_DRV|GND_LOGIC x2_n5 OUT GND_DRV|GND_LOGIC nfet L=0.7U W=10U AS=2.1P
+ AD=2.1P PS=10.42U PD=10.42U
* device instance $289 r0 *1 50.05,455.98 nfet
M$289 OUT x2_n5 GND_DRV|GND_LOGIC GND_DRV|GND_LOGIC nfet L=0.7U W=10U AS=2.1P
+ AD=2.1P PS=10.42U PD=10.42U
* device instance $290 r0 *1 51.17,455.98 nfet
M$290 GND_DRV|GND_LOGIC x2_n5 OUT GND_DRV|GND_LOGIC nfet L=0.7U W=10U AS=2.1P
+ AD=2.1P PS=10.42U PD=10.42U
* device instance $291 r0 *1 52.29,455.98 nfet
M$291 OUT x2_n5 GND_DRV|GND_LOGIC GND_DRV|GND_LOGIC nfet L=0.7U W=10U AS=2.1P
+ AD=2.1P PS=10.42U PD=10.42U
* device instance $292 r0 *1 53.41,455.98 nfet
M$292 GND_DRV|GND_LOGIC x2_n5 OUT GND_DRV|GND_LOGIC nfet L=0.7U W=10U AS=2.1P
+ AD=2.1P PS=10.42U PD=10.42U
* device instance $293 r0 *1 54.53,455.98 nfet
M$293 OUT x2_n5 GND_DRV|GND_LOGIC GND_DRV|GND_LOGIC nfet L=0.7U W=10U AS=2.1P
+ AD=2.1P PS=10.42U PD=10.42U
* device instance $294 r0 *1 55.65,455.98 nfet
M$294 GND_DRV|GND_LOGIC x2_n5 OUT GND_DRV|GND_LOGIC nfet L=0.7U W=10U AS=2.1P
+ AD=2.1P PS=10.42U PD=10.42U
* device instance $295 r0 *1 56.77,455.98 nfet
M$295 OUT x2_n5 GND_DRV|GND_LOGIC GND_DRV|GND_LOGIC nfet L=0.7U W=10U AS=2.1P
+ AD=2.1P PS=10.42U PD=10.42U
* device instance $296 r0 *1 57.89,455.98 nfet
M$296 GND_DRV|GND_LOGIC x2_n5 OUT GND_DRV|GND_LOGIC nfet L=0.7U W=10U AS=2.1P
+ AD=2.1P PS=10.42U PD=10.42U
* device instance $297 r0 *1 59.01,455.98 nfet
M$297 OUT x2_n5 GND_DRV|GND_LOGIC GND_DRV|GND_LOGIC nfet L=0.7U W=10U AS=2.1P
+ AD=2.1P PS=10.42U PD=10.42U
* device instance $298 r0 *1 60.13,455.98 nfet
M$298 GND_DRV|GND_LOGIC x2_n5 OUT GND_DRV|GND_LOGIC nfet L=0.7U W=10U AS=2.1P
+ AD=2.1P PS=10.42U PD=10.42U
* device instance $299 r0 *1 61.25,455.98 nfet
M$299 OUT x2_n5 GND_DRV|GND_LOGIC GND_DRV|GND_LOGIC nfet L=0.7U W=10U AS=2.1P
+ AD=2.1P PS=10.42U PD=10.42U
* device instance $300 r0 *1 0.56,14.17 pfet
M$300 x1_inb IN VDD_LOGIC VDD_LOGIC pfet L=0.28U W=10U AS=4.2P AD=4.2P
+ PS=20.84U PD=20.84U
* device instance $301 r0 *1 0.695,137.87 pfet
M$301 x1_nca x1_ncb VDD_DRV VDD_DRV pfet L=0.55U W=3U AS=1.26P AD=1.26P
+ PS=6.84U PD=6.84U
* device instance $302 r0 *1 0.695,145.19 pfet
M$302 x1_ncb x1_nca VDD_DRV VDD_DRV pfet L=0.55U W=3U AS=1.26P AD=1.26P
+ PS=6.84U PD=6.84U
* device instance $303 r0 *1 0.695,153.51 pfet
M$303 x1_nbuf1 x1_ncb VDD_DRV VDD_DRV pfet L=0.55U W=5U AS=2.1P AD=2.1P
+ PS=10.84U PD=10.84U
* device instance $304 r0 *1 0.695,176.85 pfet
M$304 IN_DRV x1_nbuf1 VDD_DRV VDD_DRV pfet L=0.55U W=15U AS=6.3P AD=6.3P
+ PS=30.84U PD=30.84U
* device instance $305 r0 *1 0.695,209.89 pfet
M$305 x2_n1 IN_DRV VDD_DRV VDD_DRV pfet L=0.55U W=4.4U AS=1.848P AD=1.848P
+ PS=9.64U PD=9.64U
* device instance $306 r0 *1 0.695,231.43 pfet
M$306 x2_n2 x2_n1 VDD_DRV VDD_DRV pfet L=0.55U W=18U AS=7.56P AD=7.56P
+ PS=36.84U PD=36.84U
* device instance $307 r0 *1 0.695,293.27 pfet
M$307 x2_n3 x2_n2 VDD_DRV VDD_DRV pfet L=0.55U W=73U AS=30.66P AD=30.66P
+ PS=146.84U PD=146.84U
* device instance $308 r0 *1 0.695,376.93 pfet
M$308 x2_n4 x2_n3 VDD_DRV VDD_DRV pfet L=0.55U W=10U AS=4.2P AD=2.1P PS=20.84U
+ PD=10.42U
* device instance $309 r0 *1 1.665,376.93 pfet
M$309 VDD_DRV x2_n3 x2_n4 VDD_DRV pfet L=0.55U W=10U AS=2.1P AD=2.1P PS=10.42U
+ PD=10.42U
* device instance $310 r0 *1 2.635,376.93 pfet
M$310 x2_n4 x2_n3 VDD_DRV VDD_DRV pfet L=0.55U W=10U AS=2.1P AD=2.1P PS=10.42U
+ PD=10.42U
* device instance $311 r0 *1 3.605,376.93 pfet
M$311 VDD_DRV x2_n3 x2_n4 VDD_DRV pfet L=0.55U W=10U AS=2.1P AD=2.1P PS=10.42U
+ PD=10.42U
* device instance $312 r0 *1 4.575,376.93 pfet
M$312 x2_n4 x2_n3 VDD_DRV VDD_DRV pfet L=0.55U W=10U AS=2.1P AD=2.1P PS=10.42U
+ PD=10.42U
* device instance $313 r0 *1 5.545,376.93 pfet
M$313 VDD_DRV x2_n3 x2_n4 VDD_DRV pfet L=0.55U W=10U AS=2.1P AD=2.1P PS=10.42U
+ PD=10.42U
* device instance $314 r0 *1 6.515,376.93 pfet
M$314 x2_n4 x2_n3 VDD_DRV VDD_DRV pfet L=0.55U W=10U AS=2.1P AD=2.1P PS=10.42U
+ PD=10.42U
* device instance $315 r0 *1 7.485,376.93 pfet
M$315 VDD_DRV x2_n3 x2_n4 VDD_DRV pfet L=0.55U W=10U AS=2.1P AD=2.1P PS=10.42U
+ PD=10.42U
* device instance $316 r0 *1 8.455,376.93 pfet
M$316 x2_n4 x2_n3 VDD_DRV VDD_DRV pfet L=0.55U W=10U AS=2.1P AD=2.1P PS=10.42U
+ PD=10.42U
* device instance $317 r0 *1 9.425,376.93 pfet
M$317 VDD_DRV x2_n3 x2_n4 VDD_DRV pfet L=0.55U W=10U AS=2.1P AD=2.1P PS=10.42U
+ PD=10.42U
* device instance $318 r0 *1 10.395,376.93 pfet
M$318 x2_n4 x2_n3 VDD_DRV VDD_DRV pfet L=0.55U W=10U AS=2.1P AD=2.1P PS=10.42U
+ PD=10.42U
* device instance $319 r0 *1 11.365,376.93 pfet
M$319 VDD_DRV x2_n3 x2_n4 VDD_DRV pfet L=0.55U W=10U AS=2.1P AD=2.1P PS=10.42U
+ PD=10.42U
* device instance $320 r0 *1 12.335,376.93 pfet
M$320 x2_n4 x2_n3 VDD_DRV VDD_DRV pfet L=0.55U W=10U AS=2.1P AD=2.1P PS=10.42U
+ PD=10.42U
* device instance $321 r0 *1 13.305,376.93 pfet
M$321 VDD_DRV x2_n3 x2_n4 VDD_DRV pfet L=0.55U W=10U AS=2.1P AD=2.1P PS=10.42U
+ PD=10.42U
* device instance $322 r0 *1 14.275,376.93 pfet
M$322 x2_n4 x2_n3 VDD_DRV VDD_DRV pfet L=0.55U W=10U AS=2.1P AD=2.1P PS=10.42U
+ PD=10.42U
* device instance $323 r0 *1 15.245,376.93 pfet
M$323 VDD_DRV x2_n3 x2_n4 VDD_DRV pfet L=0.55U W=10U AS=2.1P AD=2.1P PS=10.42U
+ PD=10.42U
* device instance $324 r0 *1 16.215,376.93 pfet
M$324 x2_n4 x2_n3 VDD_DRV VDD_DRV pfet L=0.55U W=10U AS=2.1P AD=2.1P PS=10.42U
+ PD=10.42U
* device instance $325 r0 *1 17.185,376.93 pfet
M$325 VDD_DRV x2_n3 x2_n4 VDD_DRV pfet L=0.55U W=10U AS=2.1P AD=2.1P PS=10.42U
+ PD=10.42U
* device instance $326 r0 *1 18.155,376.93 pfet
M$326 x2_n4 x2_n3 VDD_DRV VDD_DRV pfet L=0.55U W=10U AS=2.1P AD=2.1P PS=10.42U
+ PD=10.42U
* device instance $327 r0 *1 19.125,376.93 pfet
M$327 VDD_DRV x2_n3 x2_n4 VDD_DRV pfet L=0.55U W=10U AS=2.1P AD=2.1P PS=10.42U
+ PD=10.42U
* device instance $328 r0 *1 20.095,376.93 pfet
M$328 x2_n4 x2_n3 VDD_DRV VDD_DRV pfet L=0.55U W=10U AS=2.1P AD=2.1P PS=10.42U
+ PD=10.42U
* device instance $329 r0 *1 21.065,376.93 pfet
M$329 VDD_DRV x2_n3 x2_n4 VDD_DRV pfet L=0.55U W=10U AS=2.1P AD=2.1P PS=10.42U
+ PD=10.42U
* device instance $330 r0 *1 22.035,376.93 pfet
M$330 x2_n4 x2_n3 VDD_DRV VDD_DRV pfet L=0.55U W=10U AS=2.1P AD=2.1P PS=10.42U
+ PD=10.42U
* device instance $331 r0 *1 23.005,376.93 pfet
M$331 VDD_DRV x2_n3 x2_n4 VDD_DRV pfet L=0.55U W=10U AS=2.1P AD=2.1P PS=10.42U
+ PD=10.42U
* device instance $332 r0 *1 23.975,376.93 pfet
M$332 x2_n4 x2_n3 VDD_DRV VDD_DRV pfet L=0.55U W=10U AS=2.1P AD=2.1P PS=10.42U
+ PD=10.42U
* device instance $333 r0 *1 24.945,376.93 pfet
M$333 VDD_DRV x2_n3 x2_n4 VDD_DRV pfet L=0.55U W=10U AS=2.1P AD=2.1P PS=10.42U
+ PD=10.42U
* device instance $334 r0 *1 25.915,376.93 pfet
M$334 x2_n4 x2_n3 VDD_DRV VDD_DRV pfet L=0.55U W=10U AS=2.1P AD=2.1P PS=10.42U
+ PD=10.42U
* device instance $335 r0 *1 26.885,376.93 pfet
M$335 VDD_DRV x2_n3 x2_n4 VDD_DRV pfet L=0.55U W=10U AS=2.1P AD=2.1P PS=10.42U
+ PD=10.42U
* device instance $336 r0 *1 27.855,376.93 pfet
M$336 x2_n4 x2_n3 VDD_DRV VDD_DRV pfet L=0.55U W=10U AS=2.1P AD=2.1P PS=10.42U
+ PD=10.42U
* device instance $337 r0 *1 28.825,376.93 pfet
M$337 VDD_DRV x2_n3 x2_n4 VDD_DRV pfet L=0.55U W=10U AS=2.1P AD=4.2P PS=10.42U
+ PD=20.84U
* device instance $338 r0 *1 59.865,408.55 pfet
M$338 VDD_DRV x2_n4 x2_n5 VDD_DRV pfet L=0.55U W=10U AS=2.1P AD=2.1P PS=10.42U
+ PD=10.42U
* device instance $339 r0 *1 60.835,408.55 pfet
M$339 x2_n5 x2_n4 VDD_DRV VDD_DRV pfet L=0.55U W=10U AS=2.1P AD=2.1P PS=10.42U
+ PD=10.42U
* device instance $340 r0 *1 61.805,408.55 pfet
M$340 VDD_DRV x2_n4 x2_n5 VDD_DRV pfet L=0.55U W=10U AS=2.1P AD=2.1P PS=10.42U
+ PD=10.42U
* device instance $341 r0 *1 62.775,408.55 pfet
M$341 x2_n5 x2_n4 VDD_DRV VDD_DRV pfet L=0.55U W=10U AS=2.1P AD=2.1P PS=10.42U
+ PD=10.42U
* device instance $342 r0 *1 63.745,408.55 pfet
M$342 VDD_DRV x2_n4 x2_n5 VDD_DRV pfet L=0.55U W=10U AS=2.1P AD=2.1P PS=10.42U
+ PD=10.42U
* device instance $343 r0 *1 64.715,408.55 pfet
M$343 x2_n5 x2_n4 VDD_DRV VDD_DRV pfet L=0.55U W=10U AS=2.1P AD=2.1P PS=10.42U
+ PD=10.42U
* device instance $344 r0 *1 65.685,408.55 pfet
M$344 VDD_DRV x2_n4 x2_n5 VDD_DRV pfet L=0.55U W=10U AS=2.1P AD=2.1P PS=10.42U
+ PD=10.42U
* device instance $345 r0 *1 66.655,408.55 pfet
M$345 x2_n5 x2_n4 VDD_DRV VDD_DRV pfet L=0.55U W=10U AS=2.1P AD=2.1P PS=10.42U
+ PD=10.42U
* device instance $346 r0 *1 67.625,408.55 pfet
M$346 VDD_DRV x2_n4 x2_n5 VDD_DRV pfet L=0.55U W=10U AS=2.1P AD=2.1P PS=10.42U
+ PD=10.42U
* device instance $347 r0 *1 68.595,408.55 pfet
M$347 x2_n5 x2_n4 VDD_DRV VDD_DRV pfet L=0.55U W=10U AS=2.1P AD=2.1P PS=10.42U
+ PD=10.42U
* device instance $348 r0 *1 69.565,408.55 pfet
M$348 VDD_DRV x2_n4 x2_n5 VDD_DRV pfet L=0.55U W=10U AS=2.1P AD=2.1P PS=10.42U
+ PD=10.42U
* device instance $349 r0 *1 70.535,408.55 pfet
M$349 x2_n5 x2_n4 VDD_DRV VDD_DRV pfet L=0.55U W=10U AS=2.1P AD=2.1P PS=10.42U
+ PD=10.42U
* device instance $350 r0 *1 71.505,408.55 pfet
M$350 VDD_DRV x2_n4 x2_n5 VDD_DRV pfet L=0.55U W=10U AS=2.1P AD=2.1P PS=10.42U
+ PD=10.42U
* device instance $351 r0 *1 72.475,408.55 pfet
M$351 x2_n5 x2_n4 VDD_DRV VDD_DRV pfet L=0.55U W=10U AS=2.1P AD=2.1P PS=10.42U
+ PD=10.42U
* device instance $352 r0 *1 73.445,408.55 pfet
M$352 VDD_DRV x2_n4 x2_n5 VDD_DRV pfet L=0.55U W=10U AS=2.1P AD=2.1P PS=10.42U
+ PD=10.42U
* device instance $353 r0 *1 74.415,408.55 pfet
M$353 x2_n5 x2_n4 VDD_DRV VDD_DRV pfet L=0.55U W=10U AS=2.1P AD=2.1P PS=10.42U
+ PD=10.42U
* device instance $354 r0 *1 75.385,408.55 pfet
M$354 VDD_DRV x2_n4 x2_n5 VDD_DRV pfet L=0.55U W=10U AS=2.1P AD=2.1P PS=10.42U
+ PD=10.42U
* device instance $355 r0 *1 76.355,408.55 pfet
M$355 x2_n5 x2_n4 VDD_DRV VDD_DRV pfet L=0.55U W=10U AS=2.1P AD=2.1P PS=10.42U
+ PD=10.42U
* device instance $356 r0 *1 77.325,408.55 pfet
M$356 VDD_DRV x2_n4 x2_n5 VDD_DRV pfet L=0.55U W=10U AS=2.1P AD=2.1P PS=10.42U
+ PD=10.42U
* device instance $357 r0 *1 78.295,408.55 pfet
M$357 x2_n5 x2_n4 VDD_DRV VDD_DRV pfet L=0.55U W=10U AS=2.1P AD=2.1P PS=10.42U
+ PD=10.42U
* device instance $358 r0 *1 79.265,408.55 pfet
M$358 VDD_DRV x2_n4 x2_n5 VDD_DRV pfet L=0.55U W=10U AS=2.1P AD=2.1P PS=10.42U
+ PD=10.42U
* device instance $359 r0 *1 80.235,408.55 pfet
M$359 x2_n5 x2_n4 VDD_DRV VDD_DRV pfet L=0.55U W=10U AS=2.1P AD=2.1P PS=10.42U
+ PD=10.42U
* device instance $360 r0 *1 81.205,408.55 pfet
M$360 VDD_DRV x2_n4 x2_n5 VDD_DRV pfet L=0.55U W=10U AS=2.1P AD=2.1P PS=10.42U
+ PD=10.42U
* device instance $361 r0 *1 82.175,408.55 pfet
M$361 x2_n5 x2_n4 VDD_DRV VDD_DRV pfet L=0.55U W=10U AS=2.1P AD=2.1P PS=10.42U
+ PD=10.42U
* device instance $362 r0 *1 83.145,408.55 pfet
M$362 VDD_DRV x2_n4 x2_n5 VDD_DRV pfet L=0.55U W=10U AS=2.1P AD=2.1P PS=10.42U
+ PD=10.42U
* device instance $363 r0 *1 84.115,408.55 pfet
M$363 x2_n5 x2_n4 VDD_DRV VDD_DRV pfet L=0.55U W=10U AS=2.1P AD=2.1P PS=10.42U
+ PD=10.42U
* device instance $364 r0 *1 85.085,408.55 pfet
M$364 VDD_DRV x2_n4 x2_n5 VDD_DRV pfet L=0.55U W=10U AS=2.1P AD=2.1P PS=10.42U
+ PD=10.42U
* device instance $365 r0 *1 86.055,408.55 pfet
M$365 x2_n5 x2_n4 VDD_DRV VDD_DRV pfet L=0.55U W=10U AS=2.1P AD=2.1P PS=10.42U
+ PD=10.42U
* device instance $366 r0 *1 87.025,408.55 pfet
M$366 VDD_DRV x2_n4 x2_n5 VDD_DRV pfet L=0.55U W=10U AS=2.1P AD=2.1P PS=10.42U
+ PD=10.42U
* device instance $367 r0 *1 87.995,408.55 pfet
M$367 x2_n5 x2_n4 VDD_DRV VDD_DRV pfet L=0.55U W=10U AS=2.1P AD=2.1P PS=10.42U
+ PD=10.42U
* device instance $368 r0 *1 88.965,408.55 pfet
M$368 VDD_DRV x2_n4 x2_n5 VDD_DRV pfet L=0.55U W=10U AS=2.1P AD=2.1P PS=10.42U
+ PD=10.42U
* device instance $369 r0 *1 89.935,408.55 pfet
M$369 x2_n5 x2_n4 VDD_DRV VDD_DRV pfet L=0.55U W=10U AS=2.1P AD=2.1P PS=10.42U
+ PD=10.42U
* device instance $370 r0 *1 90.905,408.55 pfet
M$370 VDD_DRV x2_n4 x2_n5 VDD_DRV pfet L=0.55U W=10U AS=2.1P AD=2.1P PS=10.42U
+ PD=10.42U
* device instance $371 r0 *1 91.875,408.55 pfet
M$371 x2_n5 x2_n4 VDD_DRV VDD_DRV pfet L=0.55U W=10U AS=2.1P AD=2.1P PS=10.42U
+ PD=10.42U
* device instance $372 r0 *1 92.845,408.55 pfet
M$372 VDD_DRV x2_n4 x2_n5 VDD_DRV pfet L=0.55U W=10U AS=2.1P AD=2.1P PS=10.42U
+ PD=10.42U
* device instance $373 r0 *1 93.815,408.55 pfet
M$373 x2_n5 x2_n4 VDD_DRV VDD_DRV pfet L=0.55U W=10U AS=2.1P AD=2.1P PS=10.42U
+ PD=10.42U
* device instance $374 r0 *1 94.785,408.55 pfet
M$374 VDD_DRV x2_n4 x2_n5 VDD_DRV pfet L=0.55U W=10U AS=2.1P AD=2.1P PS=10.42U
+ PD=10.42U
* device instance $375 r0 *1 95.755,408.55 pfet
M$375 x2_n5 x2_n4 VDD_DRV VDD_DRV pfet L=0.55U W=10U AS=2.1P AD=2.1P PS=10.42U
+ PD=10.42U
* device instance $376 r0 *1 96.725,408.55 pfet
M$376 VDD_DRV x2_n4 x2_n5 VDD_DRV pfet L=0.55U W=10U AS=2.1P AD=2.1P PS=10.42U
+ PD=10.42U
* device instance $377 r0 *1 97.695,408.55 pfet
M$377 x2_n5 x2_n4 VDD_DRV VDD_DRV pfet L=0.55U W=10U AS=2.1P AD=2.1P PS=10.42U
+ PD=10.42U
* device instance $378 r0 *1 98.665,408.55 pfet
M$378 VDD_DRV x2_n4 x2_n5 VDD_DRV pfet L=0.55U W=10U AS=2.1P AD=2.1P PS=10.42U
+ PD=10.42U
* device instance $379 r0 *1 99.635,408.55 pfet
M$379 x2_n5 x2_n4 VDD_DRV VDD_DRV pfet L=0.55U W=10U AS=2.1P AD=2.1P PS=10.42U
+ PD=10.42U
* device instance $380 r0 *1 100.605,408.55 pfet
M$380 VDD_DRV x2_n4 x2_n5 VDD_DRV pfet L=0.55U W=10U AS=2.1P AD=2.1P PS=10.42U
+ PD=10.42U
* device instance $381 r0 *1 101.575,408.55 pfet
M$381 x2_n5 x2_n4 VDD_DRV VDD_DRV pfet L=0.55U W=10U AS=2.1P AD=2.1P PS=10.42U
+ PD=10.42U
* device instance $382 r0 *1 102.545,408.55 pfet
M$382 VDD_DRV x2_n4 x2_n5 VDD_DRV pfet L=0.55U W=10U AS=2.1P AD=2.1P PS=10.42U
+ PD=10.42U
* device instance $383 r0 *1 103.515,408.55 pfet
M$383 x2_n5 x2_n4 VDD_DRV VDD_DRV pfet L=0.55U W=10U AS=2.1P AD=2.1P PS=10.42U
+ PD=10.42U
* device instance $384 r0 *1 104.485,408.55 pfet
M$384 VDD_DRV x2_n4 x2_n5 VDD_DRV pfet L=0.55U W=10U AS=2.1P AD=2.1P PS=10.42U
+ PD=10.42U
* device instance $385 r0 *1 105.455,408.55 pfet
M$385 x2_n5 x2_n4 VDD_DRV VDD_DRV pfet L=0.55U W=10U AS=2.1P AD=2.1P PS=10.42U
+ PD=10.42U
* device instance $386 r0 *1 106.425,408.55 pfet
M$386 VDD_DRV x2_n4 x2_n5 VDD_DRV pfet L=0.55U W=10U AS=2.1P AD=2.1P PS=10.42U
+ PD=10.42U
* device instance $387 r0 *1 107.395,408.55 pfet
M$387 x2_n5 x2_n4 VDD_DRV VDD_DRV pfet L=0.55U W=10U AS=2.1P AD=2.1P PS=10.42U
+ PD=10.42U
* device instance $388 r0 *1 108.365,408.55 pfet
M$388 VDD_DRV x2_n4 x2_n5 VDD_DRV pfet L=0.55U W=10U AS=2.1P AD=2.1P PS=10.42U
+ PD=10.42U
* device instance $389 r0 *1 109.335,408.55 pfet
M$389 x2_n5 x2_n4 VDD_DRV VDD_DRV pfet L=0.55U W=10U AS=2.1P AD=2.1P PS=10.42U
+ PD=10.42U
* device instance $390 r0 *1 110.305,408.55 pfet
M$390 VDD_DRV x2_n4 x2_n5 VDD_DRV pfet L=0.55U W=10U AS=2.1P AD=2.1P PS=10.42U
+ PD=10.42U
* device instance $391 r0 *1 111.275,408.55 pfet
M$391 x2_n5 x2_n4 VDD_DRV VDD_DRV pfet L=0.55U W=10U AS=2.1P AD=2.1P PS=10.42U
+ PD=10.42U
* device instance $392 r0 *1 112.245,408.55 pfet
M$392 VDD_DRV x2_n4 x2_n5 VDD_DRV pfet L=0.55U W=10U AS=2.1P AD=2.1P PS=10.42U
+ PD=10.42U
* device instance $393 r0 *1 113.215,408.55 pfet
M$393 x2_n5 x2_n4 VDD_DRV VDD_DRV pfet L=0.55U W=10U AS=2.1P AD=2.1P PS=10.42U
+ PD=10.42U
* device instance $394 r0 *1 114.185,408.55 pfet
M$394 VDD_DRV x2_n4 x2_n5 VDD_DRV pfet L=0.55U W=10U AS=2.1P AD=2.1P PS=10.42U
+ PD=10.42U
* device instance $395 r0 *1 115.155,408.55 pfet
M$395 x2_n5 x2_n4 VDD_DRV VDD_DRV pfet L=0.55U W=10U AS=2.1P AD=2.1P PS=10.42U
+ PD=10.42U
* device instance $396 r0 *1 116.125,408.55 pfet
M$396 VDD_DRV x2_n4 x2_n5 VDD_DRV pfet L=0.55U W=10U AS=2.1P AD=2.1P PS=10.42U
+ PD=10.42U
* device instance $397 r0 *1 117.095,408.55 pfet
M$397 x2_n5 x2_n4 VDD_DRV VDD_DRV pfet L=0.55U W=10U AS=2.1P AD=2.1P PS=10.42U
+ PD=10.42U
* device instance $398 r0 *1 118.065,408.55 pfet
M$398 VDD_DRV x2_n4 x2_n5 VDD_DRV pfet L=0.55U W=10U AS=2.1P AD=4.2P PS=10.42U
+ PD=20.84U
* device instance $399 r0 *1 0.695,408.55 pfet
M$399 x2_n5 x2_n4 VDD_DRV VDD_DRV pfet L=0.55U W=10U AS=4.2P AD=2.1P PS=20.84U
+ PD=10.42U
* device instance $400 r0 *1 1.665,408.55 pfet
M$400 VDD_DRV x2_n4 x2_n5 VDD_DRV pfet L=0.55U W=10U AS=2.1P AD=2.1P PS=10.42U
+ PD=10.42U
* device instance $401 r0 *1 2.635,408.55 pfet
M$401 x2_n5 x2_n4 VDD_DRV VDD_DRV pfet L=0.55U W=10U AS=2.1P AD=2.1P PS=10.42U
+ PD=10.42U
* device instance $402 r0 *1 3.605,408.55 pfet
M$402 VDD_DRV x2_n4 x2_n5 VDD_DRV pfet L=0.55U W=10U AS=2.1P AD=2.1P PS=10.42U
+ PD=10.42U
* device instance $403 r0 *1 4.575,408.55 pfet
M$403 x2_n5 x2_n4 VDD_DRV VDD_DRV pfet L=0.55U W=10U AS=2.1P AD=2.1P PS=10.42U
+ PD=10.42U
* device instance $404 r0 *1 5.545,408.55 pfet
M$404 VDD_DRV x2_n4 x2_n5 VDD_DRV pfet L=0.55U W=10U AS=2.1P AD=2.1P PS=10.42U
+ PD=10.42U
* device instance $405 r0 *1 6.515,408.55 pfet
M$405 x2_n5 x2_n4 VDD_DRV VDD_DRV pfet L=0.55U W=10U AS=2.1P AD=2.1P PS=10.42U
+ PD=10.42U
* device instance $406 r0 *1 7.485,408.55 pfet
M$406 VDD_DRV x2_n4 x2_n5 VDD_DRV pfet L=0.55U W=10U AS=2.1P AD=2.1P PS=10.42U
+ PD=10.42U
* device instance $407 r0 *1 8.455,408.55 pfet
M$407 x2_n5 x2_n4 VDD_DRV VDD_DRV pfet L=0.55U W=10U AS=2.1P AD=2.1P PS=10.42U
+ PD=10.42U
* device instance $408 r0 *1 9.425,408.55 pfet
M$408 VDD_DRV x2_n4 x2_n5 VDD_DRV pfet L=0.55U W=10U AS=2.1P AD=2.1P PS=10.42U
+ PD=10.42U
* device instance $409 r0 *1 10.395,408.55 pfet
M$409 x2_n5 x2_n4 VDD_DRV VDD_DRV pfet L=0.55U W=10U AS=2.1P AD=2.1P PS=10.42U
+ PD=10.42U
* device instance $410 r0 *1 11.365,408.55 pfet
M$410 VDD_DRV x2_n4 x2_n5 VDD_DRV pfet L=0.55U W=10U AS=2.1P AD=2.1P PS=10.42U
+ PD=10.42U
* device instance $411 r0 *1 12.335,408.55 pfet
M$411 x2_n5 x2_n4 VDD_DRV VDD_DRV pfet L=0.55U W=10U AS=2.1P AD=2.1P PS=10.42U
+ PD=10.42U
* device instance $412 r0 *1 13.305,408.55 pfet
M$412 VDD_DRV x2_n4 x2_n5 VDD_DRV pfet L=0.55U W=10U AS=2.1P AD=2.1P PS=10.42U
+ PD=10.42U
* device instance $413 r0 *1 14.275,408.55 pfet
M$413 x2_n5 x2_n4 VDD_DRV VDD_DRV pfet L=0.55U W=10U AS=2.1P AD=2.1P PS=10.42U
+ PD=10.42U
* device instance $414 r0 *1 15.245,408.55 pfet
M$414 VDD_DRV x2_n4 x2_n5 VDD_DRV pfet L=0.55U W=10U AS=2.1P AD=2.1P PS=10.42U
+ PD=10.42U
* device instance $415 r0 *1 16.215,408.55 pfet
M$415 x2_n5 x2_n4 VDD_DRV VDD_DRV pfet L=0.55U W=10U AS=2.1P AD=2.1P PS=10.42U
+ PD=10.42U
* device instance $416 r0 *1 17.185,408.55 pfet
M$416 VDD_DRV x2_n4 x2_n5 VDD_DRV pfet L=0.55U W=10U AS=2.1P AD=2.1P PS=10.42U
+ PD=10.42U
* device instance $417 r0 *1 18.155,408.55 pfet
M$417 x2_n5 x2_n4 VDD_DRV VDD_DRV pfet L=0.55U W=10U AS=2.1P AD=2.1P PS=10.42U
+ PD=10.42U
* device instance $418 r0 *1 19.125,408.55 pfet
M$418 VDD_DRV x2_n4 x2_n5 VDD_DRV pfet L=0.55U W=10U AS=2.1P AD=2.1P PS=10.42U
+ PD=10.42U
* device instance $419 r0 *1 20.095,408.55 pfet
M$419 x2_n5 x2_n4 VDD_DRV VDD_DRV pfet L=0.55U W=10U AS=2.1P AD=2.1P PS=10.42U
+ PD=10.42U
* device instance $420 r0 *1 21.065,408.55 pfet
M$420 VDD_DRV x2_n4 x2_n5 VDD_DRV pfet L=0.55U W=10U AS=2.1P AD=2.1P PS=10.42U
+ PD=10.42U
* device instance $421 r0 *1 22.035,408.55 pfet
M$421 x2_n5 x2_n4 VDD_DRV VDD_DRV pfet L=0.55U W=10U AS=2.1P AD=2.1P PS=10.42U
+ PD=10.42U
* device instance $422 r0 *1 23.005,408.55 pfet
M$422 VDD_DRV x2_n4 x2_n5 VDD_DRV pfet L=0.55U W=10U AS=2.1P AD=2.1P PS=10.42U
+ PD=10.42U
* device instance $423 r0 *1 23.975,408.55 pfet
M$423 x2_n5 x2_n4 VDD_DRV VDD_DRV pfet L=0.55U W=10U AS=2.1P AD=2.1P PS=10.42U
+ PD=10.42U
* device instance $424 r0 *1 24.945,408.55 pfet
M$424 VDD_DRV x2_n4 x2_n5 VDD_DRV pfet L=0.55U W=10U AS=2.1P AD=2.1P PS=10.42U
+ PD=10.42U
* device instance $425 r0 *1 25.915,408.55 pfet
M$425 x2_n5 x2_n4 VDD_DRV VDD_DRV pfet L=0.55U W=10U AS=2.1P AD=2.1P PS=10.42U
+ PD=10.42U
* device instance $426 r0 *1 26.885,408.55 pfet
M$426 VDD_DRV x2_n4 x2_n5 VDD_DRV pfet L=0.55U W=10U AS=2.1P AD=2.1P PS=10.42U
+ PD=10.42U
* device instance $427 r0 *1 27.855,408.55 pfet
M$427 x2_n5 x2_n4 VDD_DRV VDD_DRV pfet L=0.55U W=10U AS=2.1P AD=2.1P PS=10.42U
+ PD=10.42U
* device instance $428 r0 *1 28.825,408.55 pfet
M$428 VDD_DRV x2_n4 x2_n5 VDD_DRV pfet L=0.55U W=10U AS=2.1P AD=2.1P PS=10.42U
+ PD=10.42U
* device instance $429 r0 *1 29.795,408.55 pfet
M$429 x2_n5 x2_n4 VDD_DRV VDD_DRV pfet L=0.55U W=10U AS=2.1P AD=2.1P PS=10.42U
+ PD=10.42U
* device instance $430 r0 *1 30.765,408.55 pfet
M$430 VDD_DRV x2_n4 x2_n5 VDD_DRV pfet L=0.55U W=10U AS=2.1P AD=2.1P PS=10.42U
+ PD=10.42U
* device instance $431 r0 *1 31.735,408.55 pfet
M$431 x2_n5 x2_n4 VDD_DRV VDD_DRV pfet L=0.55U W=10U AS=2.1P AD=2.1P PS=10.42U
+ PD=10.42U
* device instance $432 r0 *1 32.705,408.55 pfet
M$432 VDD_DRV x2_n4 x2_n5 VDD_DRV pfet L=0.55U W=10U AS=2.1P AD=2.1P PS=10.42U
+ PD=10.42U
* device instance $433 r0 *1 33.675,408.55 pfet
M$433 x2_n5 x2_n4 VDD_DRV VDD_DRV pfet L=0.55U W=10U AS=2.1P AD=2.1P PS=10.42U
+ PD=10.42U
* device instance $434 r0 *1 34.645,408.55 pfet
M$434 VDD_DRV x2_n4 x2_n5 VDD_DRV pfet L=0.55U W=10U AS=2.1P AD=2.1P PS=10.42U
+ PD=10.42U
* device instance $435 r0 *1 35.615,408.55 pfet
M$435 x2_n5 x2_n4 VDD_DRV VDD_DRV pfet L=0.55U W=10U AS=2.1P AD=2.1P PS=10.42U
+ PD=10.42U
* device instance $436 r0 *1 36.585,408.55 pfet
M$436 VDD_DRV x2_n4 x2_n5 VDD_DRV pfet L=0.55U W=10U AS=2.1P AD=2.1P PS=10.42U
+ PD=10.42U
* device instance $437 r0 *1 37.555,408.55 pfet
M$437 x2_n5 x2_n4 VDD_DRV VDD_DRV pfet L=0.55U W=10U AS=2.1P AD=2.1P PS=10.42U
+ PD=10.42U
* device instance $438 r0 *1 38.525,408.55 pfet
M$438 VDD_DRV x2_n4 x2_n5 VDD_DRV pfet L=0.55U W=10U AS=2.1P AD=2.1P PS=10.42U
+ PD=10.42U
* device instance $439 r0 *1 39.495,408.55 pfet
M$439 x2_n5 x2_n4 VDD_DRV VDD_DRV pfet L=0.55U W=10U AS=2.1P AD=2.1P PS=10.42U
+ PD=10.42U
* device instance $440 r0 *1 40.465,408.55 pfet
M$440 VDD_DRV x2_n4 x2_n5 VDD_DRV pfet L=0.55U W=10U AS=2.1P AD=2.1P PS=10.42U
+ PD=10.42U
* device instance $441 r0 *1 41.435,408.55 pfet
M$441 x2_n5 x2_n4 VDD_DRV VDD_DRV pfet L=0.55U W=10U AS=2.1P AD=2.1P PS=10.42U
+ PD=10.42U
* device instance $442 r0 *1 42.405,408.55 pfet
M$442 VDD_DRV x2_n4 x2_n5 VDD_DRV pfet L=0.55U W=10U AS=2.1P AD=2.1P PS=10.42U
+ PD=10.42U
* device instance $443 r0 *1 43.375,408.55 pfet
M$443 x2_n5 x2_n4 VDD_DRV VDD_DRV pfet L=0.55U W=10U AS=2.1P AD=2.1P PS=10.42U
+ PD=10.42U
* device instance $444 r0 *1 44.345,408.55 pfet
M$444 VDD_DRV x2_n4 x2_n5 VDD_DRV pfet L=0.55U W=10U AS=2.1P AD=2.1P PS=10.42U
+ PD=10.42U
* device instance $445 r0 *1 45.315,408.55 pfet
M$445 x2_n5 x2_n4 VDD_DRV VDD_DRV pfet L=0.55U W=10U AS=2.1P AD=2.1P PS=10.42U
+ PD=10.42U
* device instance $446 r0 *1 46.285,408.55 pfet
M$446 VDD_DRV x2_n4 x2_n5 VDD_DRV pfet L=0.55U W=10U AS=2.1P AD=2.1P PS=10.42U
+ PD=10.42U
* device instance $447 r0 *1 47.255,408.55 pfet
M$447 x2_n5 x2_n4 VDD_DRV VDD_DRV pfet L=0.55U W=10U AS=2.1P AD=2.1P PS=10.42U
+ PD=10.42U
* device instance $448 r0 *1 48.225,408.55 pfet
M$448 VDD_DRV x2_n4 x2_n5 VDD_DRV pfet L=0.55U W=10U AS=2.1P AD=2.1P PS=10.42U
+ PD=10.42U
* device instance $449 r0 *1 49.195,408.55 pfet
M$449 x2_n5 x2_n4 VDD_DRV VDD_DRV pfet L=0.55U W=10U AS=2.1P AD=2.1P PS=10.42U
+ PD=10.42U
* device instance $450 r0 *1 50.165,408.55 pfet
M$450 VDD_DRV x2_n4 x2_n5 VDD_DRV pfet L=0.55U W=10U AS=2.1P AD=2.1P PS=10.42U
+ PD=10.42U
* device instance $451 r0 *1 51.135,408.55 pfet
M$451 x2_n5 x2_n4 VDD_DRV VDD_DRV pfet L=0.55U W=10U AS=2.1P AD=2.1P PS=10.42U
+ PD=10.42U
* device instance $452 r0 *1 52.105,408.55 pfet
M$452 VDD_DRV x2_n4 x2_n5 VDD_DRV pfet L=0.55U W=10U AS=2.1P AD=2.1P PS=10.42U
+ PD=10.42U
* device instance $453 r0 *1 53.075,408.55 pfet
M$453 x2_n5 x2_n4 VDD_DRV VDD_DRV pfet L=0.55U W=10U AS=2.1P AD=2.1P PS=10.42U
+ PD=10.42U
* device instance $454 r0 *1 54.045,408.55 pfet
M$454 VDD_DRV x2_n4 x2_n5 VDD_DRV pfet L=0.55U W=10U AS=2.1P AD=2.1P PS=10.42U
+ PD=10.42U
* device instance $455 r0 *1 55.015,408.55 pfet
M$455 x2_n5 x2_n4 VDD_DRV VDD_DRV pfet L=0.55U W=10U AS=2.1P AD=2.1P PS=10.42U
+ PD=10.42U
* device instance $456 r0 *1 55.985,408.55 pfet
M$456 VDD_DRV x2_n4 x2_n5 VDD_DRV pfet L=0.55U W=10U AS=2.1P AD=2.1P PS=10.42U
+ PD=10.42U
* device instance $457 r0 *1 56.955,408.55 pfet
M$457 x2_n5 x2_n4 VDD_DRV VDD_DRV pfet L=0.55U W=10U AS=2.1P AD=2.1P PS=10.42U
+ PD=10.42U
* device instance $458 r0 *1 57.925,408.55 pfet
M$458 VDD_DRV x2_n4 x2_n5 VDD_DRV pfet L=0.55U W=10U AS=2.1P AD=2.1P PS=10.42U
+ PD=10.42U
* device instance $459 r0 *1 58.895,408.55 pfet
M$459 x2_n5 x2_n4 VDD_DRV VDD_DRV pfet L=0.55U W=10U AS=2.1P AD=2.1P PS=10.42U
+ PD=10.42U
* device instance $460 r0 *1 424.585,440.17 pfet
M$460 VDD_DRV x2_n5 OUT VDD_DRV pfet L=0.55U W=10U AS=2.1P AD=2.1P PS=10.42U
+ PD=10.42U
* device instance $461 r0 *1 425.555,440.17 pfet
M$461 OUT x2_n5 VDD_DRV VDD_DRV pfet L=0.55U W=10U AS=2.1P AD=2.1P PS=10.42U
+ PD=10.42U
* device instance $462 r0 *1 426.525,440.17 pfet
M$462 VDD_DRV x2_n5 OUT VDD_DRV pfet L=0.55U W=10U AS=2.1P AD=2.1P PS=10.42U
+ PD=10.42U
* device instance $463 r0 *1 427.495,440.17 pfet
M$463 OUT x2_n5 VDD_DRV VDD_DRV pfet L=0.55U W=10U AS=2.1P AD=2.1P PS=10.42U
+ PD=10.42U
* device instance $464 r0 *1 428.465,440.17 pfet
M$464 VDD_DRV x2_n5 OUT VDD_DRV pfet L=0.55U W=10U AS=2.1P AD=2.1P PS=10.42U
+ PD=10.42U
* device instance $465 r0 *1 429.435,440.17 pfet
M$465 OUT x2_n5 VDD_DRV VDD_DRV pfet L=0.55U W=10U AS=2.1P AD=2.1P PS=10.42U
+ PD=10.42U
* device instance $466 r0 *1 430.405,440.17 pfet
M$466 VDD_DRV x2_n5 OUT VDD_DRV pfet L=0.55U W=10U AS=2.1P AD=2.1P PS=10.42U
+ PD=10.42U
* device instance $467 r0 *1 431.375,440.17 pfet
M$467 OUT x2_n5 VDD_DRV VDD_DRV pfet L=0.55U W=10U AS=2.1P AD=2.1P PS=10.42U
+ PD=10.42U
* device instance $468 r0 *1 432.345,440.17 pfet
M$468 VDD_DRV x2_n5 OUT VDD_DRV pfet L=0.55U W=10U AS=2.1P AD=2.1P PS=10.42U
+ PD=10.42U
* device instance $469 r0 *1 433.315,440.17 pfet
M$469 OUT x2_n5 VDD_DRV VDD_DRV pfet L=0.55U W=10U AS=2.1P AD=2.1P PS=10.42U
+ PD=10.42U
* device instance $470 r0 *1 434.285,440.17 pfet
M$470 VDD_DRV x2_n5 OUT VDD_DRV pfet L=0.55U W=10U AS=2.1P AD=2.1P PS=10.42U
+ PD=10.42U
* device instance $471 r0 *1 435.255,440.17 pfet
M$471 OUT x2_n5 VDD_DRV VDD_DRV pfet L=0.55U W=10U AS=2.1P AD=2.1P PS=10.42U
+ PD=10.42U
* device instance $472 r0 *1 436.225,440.17 pfet
M$472 VDD_DRV x2_n5 OUT VDD_DRV pfet L=0.55U W=10U AS=2.1P AD=2.1P PS=10.42U
+ PD=10.42U
* device instance $473 r0 *1 437.195,440.17 pfet
M$473 OUT x2_n5 VDD_DRV VDD_DRV pfet L=0.55U W=10U AS=2.1P AD=2.1P PS=10.42U
+ PD=10.42U
* device instance $474 r0 *1 438.165,440.17 pfet
M$474 VDD_DRV x2_n5 OUT VDD_DRV pfet L=0.55U W=10U AS=2.1P AD=2.1P PS=10.42U
+ PD=10.42U
* device instance $475 r0 *1 439.135,440.17 pfet
M$475 OUT x2_n5 VDD_DRV VDD_DRV pfet L=0.55U W=10U AS=2.1P AD=2.1P PS=10.42U
+ PD=10.42U
* device instance $476 r0 *1 440.105,440.17 pfet
M$476 VDD_DRV x2_n5 OUT VDD_DRV pfet L=0.55U W=10U AS=2.1P AD=2.1P PS=10.42U
+ PD=10.42U
* device instance $477 r0 *1 441.075,440.17 pfet
M$477 OUT x2_n5 VDD_DRV VDD_DRV pfet L=0.55U W=10U AS=2.1P AD=2.1P PS=10.42U
+ PD=10.42U
* device instance $478 r0 *1 442.045,440.17 pfet
M$478 VDD_DRV x2_n5 OUT VDD_DRV pfet L=0.55U W=10U AS=2.1P AD=2.1P PS=10.42U
+ PD=10.42U
* device instance $479 r0 *1 443.015,440.17 pfet
M$479 OUT x2_n5 VDD_DRV VDD_DRV pfet L=0.55U W=10U AS=2.1P AD=2.1P PS=10.42U
+ PD=10.42U
* device instance $480 r0 *1 443.985,440.17 pfet
M$480 VDD_DRV x2_n5 OUT VDD_DRV pfet L=0.55U W=10U AS=2.1P AD=2.1P PS=10.42U
+ PD=10.42U
* device instance $481 r0 *1 444.955,440.17 pfet
M$481 OUT x2_n5 VDD_DRV VDD_DRV pfet L=0.55U W=10U AS=2.1P AD=2.1P PS=10.42U
+ PD=10.42U
* device instance $482 r0 *1 445.925,440.17 pfet
M$482 VDD_DRV x2_n5 OUT VDD_DRV pfet L=0.55U W=10U AS=2.1P AD=2.1P PS=10.42U
+ PD=10.42U
* device instance $483 r0 *1 446.895,440.17 pfet
M$483 OUT x2_n5 VDD_DRV VDD_DRV pfet L=0.55U W=10U AS=2.1P AD=2.1P PS=10.42U
+ PD=10.42U
* device instance $484 r0 *1 447.865,440.17 pfet
M$484 VDD_DRV x2_n5 OUT VDD_DRV pfet L=0.55U W=10U AS=2.1P AD=2.1P PS=10.42U
+ PD=10.42U
* device instance $485 r0 *1 448.835,440.17 pfet
M$485 OUT x2_n5 VDD_DRV VDD_DRV pfet L=0.55U W=10U AS=2.1P AD=2.1P PS=10.42U
+ PD=10.42U
* device instance $486 r0 *1 449.805,440.17 pfet
M$486 VDD_DRV x2_n5 OUT VDD_DRV pfet L=0.55U W=10U AS=2.1P AD=2.1P PS=10.42U
+ PD=10.42U
* device instance $487 r0 *1 450.775,440.17 pfet
M$487 OUT x2_n5 VDD_DRV VDD_DRV pfet L=0.55U W=10U AS=2.1P AD=2.1P PS=10.42U
+ PD=10.42U
* device instance $488 r0 *1 451.745,440.17 pfet
M$488 VDD_DRV x2_n5 OUT VDD_DRV pfet L=0.55U W=10U AS=2.1P AD=2.1P PS=10.42U
+ PD=10.42U
* device instance $489 r0 *1 452.715,440.17 pfet
M$489 OUT x2_n5 VDD_DRV VDD_DRV pfet L=0.55U W=10U AS=2.1P AD=2.1P PS=10.42U
+ PD=10.42U
* device instance $490 r0 *1 453.685,440.17 pfet
M$490 VDD_DRV x2_n5 OUT VDD_DRV pfet L=0.55U W=10U AS=2.1P AD=2.1P PS=10.42U
+ PD=10.42U
* device instance $491 r0 *1 454.655,440.17 pfet
M$491 OUT x2_n5 VDD_DRV VDD_DRV pfet L=0.55U W=10U AS=2.1P AD=2.1P PS=10.42U
+ PD=10.42U
* device instance $492 r0 *1 455.625,440.17 pfet
M$492 VDD_DRV x2_n5 OUT VDD_DRV pfet L=0.55U W=10U AS=2.1P AD=2.1P PS=10.42U
+ PD=10.42U
* device instance $493 r0 *1 456.595,440.17 pfet
M$493 OUT x2_n5 VDD_DRV VDD_DRV pfet L=0.55U W=10U AS=2.1P AD=2.1P PS=10.42U
+ PD=10.42U
* device instance $494 r0 *1 457.565,440.17 pfet
M$494 VDD_DRV x2_n5 OUT VDD_DRV pfet L=0.55U W=10U AS=2.1P AD=2.1P PS=10.42U
+ PD=10.42U
* device instance $495 r0 *1 458.535,440.17 pfet
M$495 OUT x2_n5 VDD_DRV VDD_DRV pfet L=0.55U W=10U AS=2.1P AD=2.1P PS=10.42U
+ PD=10.42U
* device instance $496 r0 *1 459.505,440.17 pfet
M$496 VDD_DRV x2_n5 OUT VDD_DRV pfet L=0.55U W=10U AS=2.1P AD=2.1P PS=10.42U
+ PD=10.42U
* device instance $497 r0 *1 460.475,440.17 pfet
M$497 OUT x2_n5 VDD_DRV VDD_DRV pfet L=0.55U W=10U AS=2.1P AD=2.1P PS=10.42U
+ PD=10.42U
* device instance $498 r0 *1 461.445,440.17 pfet
M$498 VDD_DRV x2_n5 OUT VDD_DRV pfet L=0.55U W=10U AS=2.1P AD=2.1P PS=10.42U
+ PD=10.42U
* device instance $499 r0 *1 462.415,440.17 pfet
M$499 OUT x2_n5 VDD_DRV VDD_DRV pfet L=0.55U W=10U AS=2.1P AD=2.1P PS=10.42U
+ PD=10.42U
* device instance $500 r0 *1 463.385,440.17 pfet
M$500 VDD_DRV x2_n5 OUT VDD_DRV pfet L=0.55U W=10U AS=2.1P AD=2.1P PS=10.42U
+ PD=10.42U
* device instance $501 r0 *1 464.355,440.17 pfet
M$501 OUT x2_n5 VDD_DRV VDD_DRV pfet L=0.55U W=10U AS=2.1P AD=2.1P PS=10.42U
+ PD=10.42U
* device instance $502 r0 *1 465.325,440.17 pfet
M$502 VDD_DRV x2_n5 OUT VDD_DRV pfet L=0.55U W=10U AS=2.1P AD=2.1P PS=10.42U
+ PD=10.42U
* device instance $503 r0 *1 466.295,440.17 pfet
M$503 OUT x2_n5 VDD_DRV VDD_DRV pfet L=0.55U W=10U AS=2.1P AD=2.1P PS=10.42U
+ PD=10.42U
* device instance $504 r0 *1 467.265,440.17 pfet
M$504 VDD_DRV x2_n5 OUT VDD_DRV pfet L=0.55U W=10U AS=2.1P AD=2.1P PS=10.42U
+ PD=10.42U
* device instance $505 r0 *1 468.235,440.17 pfet
M$505 OUT x2_n5 VDD_DRV VDD_DRV pfet L=0.55U W=10U AS=2.1P AD=2.1P PS=10.42U
+ PD=10.42U
* device instance $506 r0 *1 469.205,440.17 pfet
M$506 VDD_DRV x2_n5 OUT VDD_DRV pfet L=0.55U W=10U AS=2.1P AD=2.1P PS=10.42U
+ PD=10.42U
* device instance $507 r0 *1 470.175,440.17 pfet
M$507 OUT x2_n5 VDD_DRV VDD_DRV pfet L=0.55U W=10U AS=2.1P AD=2.1P PS=10.42U
+ PD=10.42U
* device instance $508 r0 *1 471.145,440.17 pfet
M$508 VDD_DRV x2_n5 OUT VDD_DRV pfet L=0.55U W=10U AS=2.1P AD=2.1P PS=10.42U
+ PD=10.42U
* device instance $509 r0 *1 472.115,440.17 pfet
M$509 OUT x2_n5 VDD_DRV VDD_DRV pfet L=0.55U W=10U AS=2.1P AD=2.1P PS=10.42U
+ PD=10.42U
* device instance $510 r0 *1 473.085,440.17 pfet
M$510 VDD_DRV x2_n5 OUT VDD_DRV pfet L=0.55U W=10U AS=2.1P AD=2.1P PS=10.42U
+ PD=10.42U
* device instance $511 r0 *1 474.055,440.17 pfet
M$511 OUT x2_n5 VDD_DRV VDD_DRV pfet L=0.55U W=10U AS=2.1P AD=2.1P PS=10.42U
+ PD=10.42U
* device instance $512 r0 *1 475.025,440.17 pfet
M$512 VDD_DRV x2_n5 OUT VDD_DRV pfet L=0.55U W=10U AS=2.1P AD=2.1P PS=10.42U
+ PD=10.42U
* device instance $513 r0 *1 475.995,440.17 pfet
M$513 OUT x2_n5 VDD_DRV VDD_DRV pfet L=0.55U W=10U AS=2.1P AD=2.1P PS=10.42U
+ PD=10.42U
* device instance $514 r0 *1 476.965,440.17 pfet
M$514 VDD_DRV x2_n5 OUT VDD_DRV pfet L=0.55U W=10U AS=2.1P AD=2.1P PS=10.42U
+ PD=10.42U
* device instance $515 r0 *1 477.935,440.17 pfet
M$515 OUT x2_n5 VDD_DRV VDD_DRV pfet L=0.55U W=10U AS=2.1P AD=2.1P PS=10.42U
+ PD=10.42U
* device instance $516 r0 *1 478.905,440.17 pfet
M$516 VDD_DRV x2_n5 OUT VDD_DRV pfet L=0.55U W=10U AS=2.1P AD=2.1P PS=10.42U
+ PD=10.42U
* device instance $517 r0 *1 479.875,440.17 pfet
M$517 OUT x2_n5 VDD_DRV VDD_DRV pfet L=0.55U W=10U AS=2.1P AD=2.1P PS=10.42U
+ PD=10.42U
* device instance $518 r0 *1 480.845,440.17 pfet
M$518 VDD_DRV x2_n5 OUT VDD_DRV pfet L=0.55U W=10U AS=2.1P AD=2.1P PS=10.42U
+ PD=10.42U
* device instance $519 r0 *1 481.815,440.17 pfet
M$519 OUT x2_n5 VDD_DRV VDD_DRV pfet L=0.55U W=10U AS=2.1P AD=2.1P PS=10.42U
+ PD=10.42U
* device instance $520 r0 *1 482.785,440.17 pfet
M$520 VDD_DRV x2_n5 OUT VDD_DRV pfet L=0.55U W=10U AS=2.1P AD=2.1P PS=10.42U
+ PD=10.42U
* device instance $521 r0 *1 483.755,440.17 pfet
M$521 OUT x2_n5 VDD_DRV VDD_DRV pfet L=0.55U W=10U AS=2.1P AD=2.1P PS=10.42U
+ PD=10.42U
* device instance $522 r0 *1 484.725,440.17 pfet
M$522 VDD_DRV x2_n5 OUT VDD_DRV pfet L=0.55U W=10U AS=2.1P AD=4.2P PS=10.42U
+ PD=20.84U
* device instance $523 r0 *1 365.415,440.17 pfet
M$523 OUT x2_n5 VDD_DRV VDD_DRV pfet L=0.55U W=10U AS=2.1P AD=2.1P PS=10.42U
+ PD=10.42U
* device instance $524 r0 *1 366.385,440.17 pfet
M$524 VDD_DRV x2_n5 OUT VDD_DRV pfet L=0.55U W=10U AS=2.1P AD=2.1P PS=10.42U
+ PD=10.42U
* device instance $525 r0 *1 367.355,440.17 pfet
M$525 OUT x2_n5 VDD_DRV VDD_DRV pfet L=0.55U W=10U AS=2.1P AD=2.1P PS=10.42U
+ PD=10.42U
* device instance $526 r0 *1 368.325,440.17 pfet
M$526 VDD_DRV x2_n5 OUT VDD_DRV pfet L=0.55U W=10U AS=2.1P AD=2.1P PS=10.42U
+ PD=10.42U
* device instance $527 r0 *1 369.295,440.17 pfet
M$527 OUT x2_n5 VDD_DRV VDD_DRV pfet L=0.55U W=10U AS=2.1P AD=2.1P PS=10.42U
+ PD=10.42U
* device instance $528 r0 *1 370.265,440.17 pfet
M$528 VDD_DRV x2_n5 OUT VDD_DRV pfet L=0.55U W=10U AS=2.1P AD=2.1P PS=10.42U
+ PD=10.42U
* device instance $529 r0 *1 371.235,440.17 pfet
M$529 OUT x2_n5 VDD_DRV VDD_DRV pfet L=0.55U W=10U AS=2.1P AD=2.1P PS=10.42U
+ PD=10.42U
* device instance $530 r0 *1 372.205,440.17 pfet
M$530 VDD_DRV x2_n5 OUT VDD_DRV pfet L=0.55U W=10U AS=2.1P AD=2.1P PS=10.42U
+ PD=10.42U
* device instance $531 r0 *1 373.175,440.17 pfet
M$531 OUT x2_n5 VDD_DRV VDD_DRV pfet L=0.55U W=10U AS=2.1P AD=2.1P PS=10.42U
+ PD=10.42U
* device instance $532 r0 *1 374.145,440.17 pfet
M$532 VDD_DRV x2_n5 OUT VDD_DRV pfet L=0.55U W=10U AS=2.1P AD=2.1P PS=10.42U
+ PD=10.42U
* device instance $533 r0 *1 375.115,440.17 pfet
M$533 OUT x2_n5 VDD_DRV VDD_DRV pfet L=0.55U W=10U AS=2.1P AD=2.1P PS=10.42U
+ PD=10.42U
* device instance $534 r0 *1 376.085,440.17 pfet
M$534 VDD_DRV x2_n5 OUT VDD_DRV pfet L=0.55U W=10U AS=2.1P AD=2.1P PS=10.42U
+ PD=10.42U
* device instance $535 r0 *1 377.055,440.17 pfet
M$535 OUT x2_n5 VDD_DRV VDD_DRV pfet L=0.55U W=10U AS=2.1P AD=2.1P PS=10.42U
+ PD=10.42U
* device instance $536 r0 *1 378.025,440.17 pfet
M$536 VDD_DRV x2_n5 OUT VDD_DRV pfet L=0.55U W=10U AS=2.1P AD=2.1P PS=10.42U
+ PD=10.42U
* device instance $537 r0 *1 378.995,440.17 pfet
M$537 OUT x2_n5 VDD_DRV VDD_DRV pfet L=0.55U W=10U AS=2.1P AD=2.1P PS=10.42U
+ PD=10.42U
* device instance $538 r0 *1 379.965,440.17 pfet
M$538 VDD_DRV x2_n5 OUT VDD_DRV pfet L=0.55U W=10U AS=2.1P AD=2.1P PS=10.42U
+ PD=10.42U
* device instance $539 r0 *1 380.935,440.17 pfet
M$539 OUT x2_n5 VDD_DRV VDD_DRV pfet L=0.55U W=10U AS=2.1P AD=2.1P PS=10.42U
+ PD=10.42U
* device instance $540 r0 *1 381.905,440.17 pfet
M$540 VDD_DRV x2_n5 OUT VDD_DRV pfet L=0.55U W=10U AS=2.1P AD=2.1P PS=10.42U
+ PD=10.42U
* device instance $541 r0 *1 382.875,440.17 pfet
M$541 OUT x2_n5 VDD_DRV VDD_DRV pfet L=0.55U W=10U AS=2.1P AD=2.1P PS=10.42U
+ PD=10.42U
* device instance $542 r0 *1 383.845,440.17 pfet
M$542 VDD_DRV x2_n5 OUT VDD_DRV pfet L=0.55U W=10U AS=2.1P AD=2.1P PS=10.42U
+ PD=10.42U
* device instance $543 r0 *1 384.815,440.17 pfet
M$543 OUT x2_n5 VDD_DRV VDD_DRV pfet L=0.55U W=10U AS=2.1P AD=2.1P PS=10.42U
+ PD=10.42U
* device instance $544 r0 *1 385.785,440.17 pfet
M$544 VDD_DRV x2_n5 OUT VDD_DRV pfet L=0.55U W=10U AS=2.1P AD=2.1P PS=10.42U
+ PD=10.42U
* device instance $545 r0 *1 386.755,440.17 pfet
M$545 OUT x2_n5 VDD_DRV VDD_DRV pfet L=0.55U W=10U AS=2.1P AD=2.1P PS=10.42U
+ PD=10.42U
* device instance $546 r0 *1 387.725,440.17 pfet
M$546 VDD_DRV x2_n5 OUT VDD_DRV pfet L=0.55U W=10U AS=2.1P AD=2.1P PS=10.42U
+ PD=10.42U
* device instance $547 r0 *1 388.695,440.17 pfet
M$547 OUT x2_n5 VDD_DRV VDD_DRV pfet L=0.55U W=10U AS=2.1P AD=2.1P PS=10.42U
+ PD=10.42U
* device instance $548 r0 *1 389.665,440.17 pfet
M$548 VDD_DRV x2_n5 OUT VDD_DRV pfet L=0.55U W=10U AS=2.1P AD=2.1P PS=10.42U
+ PD=10.42U
* device instance $549 r0 *1 390.635,440.17 pfet
M$549 OUT x2_n5 VDD_DRV VDD_DRV pfet L=0.55U W=10U AS=2.1P AD=2.1P PS=10.42U
+ PD=10.42U
* device instance $550 r0 *1 391.605,440.17 pfet
M$550 VDD_DRV x2_n5 OUT VDD_DRV pfet L=0.55U W=10U AS=2.1P AD=2.1P PS=10.42U
+ PD=10.42U
* device instance $551 r0 *1 392.575,440.17 pfet
M$551 OUT x2_n5 VDD_DRV VDD_DRV pfet L=0.55U W=10U AS=2.1P AD=2.1P PS=10.42U
+ PD=10.42U
* device instance $552 r0 *1 393.545,440.17 pfet
M$552 VDD_DRV x2_n5 OUT VDD_DRV pfet L=0.55U W=10U AS=2.1P AD=2.1P PS=10.42U
+ PD=10.42U
* device instance $553 r0 *1 394.515,440.17 pfet
M$553 OUT x2_n5 VDD_DRV VDD_DRV pfet L=0.55U W=10U AS=2.1P AD=2.1P PS=10.42U
+ PD=10.42U
* device instance $554 r0 *1 395.485,440.17 pfet
M$554 VDD_DRV x2_n5 OUT VDD_DRV pfet L=0.55U W=10U AS=2.1P AD=2.1P PS=10.42U
+ PD=10.42U
* device instance $555 r0 *1 396.455,440.17 pfet
M$555 OUT x2_n5 VDD_DRV VDD_DRV pfet L=0.55U W=10U AS=2.1P AD=2.1P PS=10.42U
+ PD=10.42U
* device instance $556 r0 *1 397.425,440.17 pfet
M$556 VDD_DRV x2_n5 OUT VDD_DRV pfet L=0.55U W=10U AS=2.1P AD=2.1P PS=10.42U
+ PD=10.42U
* device instance $557 r0 *1 398.395,440.17 pfet
M$557 OUT x2_n5 VDD_DRV VDD_DRV pfet L=0.55U W=10U AS=2.1P AD=2.1P PS=10.42U
+ PD=10.42U
* device instance $558 r0 *1 399.365,440.17 pfet
M$558 VDD_DRV x2_n5 OUT VDD_DRV pfet L=0.55U W=10U AS=2.1P AD=2.1P PS=10.42U
+ PD=10.42U
* device instance $559 r0 *1 400.335,440.17 pfet
M$559 OUT x2_n5 VDD_DRV VDD_DRV pfet L=0.55U W=10U AS=2.1P AD=2.1P PS=10.42U
+ PD=10.42U
* device instance $560 r0 *1 401.305,440.17 pfet
M$560 VDD_DRV x2_n5 OUT VDD_DRV pfet L=0.55U W=10U AS=2.1P AD=2.1P PS=10.42U
+ PD=10.42U
* device instance $561 r0 *1 402.275,440.17 pfet
M$561 OUT x2_n5 VDD_DRV VDD_DRV pfet L=0.55U W=10U AS=2.1P AD=2.1P PS=10.42U
+ PD=10.42U
* device instance $562 r0 *1 403.245,440.17 pfet
M$562 VDD_DRV x2_n5 OUT VDD_DRV pfet L=0.55U W=10U AS=2.1P AD=2.1P PS=10.42U
+ PD=10.42U
* device instance $563 r0 *1 404.215,440.17 pfet
M$563 OUT x2_n5 VDD_DRV VDD_DRV pfet L=0.55U W=10U AS=2.1P AD=2.1P PS=10.42U
+ PD=10.42U
* device instance $564 r0 *1 405.185,440.17 pfet
M$564 VDD_DRV x2_n5 OUT VDD_DRV pfet L=0.55U W=10U AS=2.1P AD=2.1P PS=10.42U
+ PD=10.42U
* device instance $565 r0 *1 406.155,440.17 pfet
M$565 OUT x2_n5 VDD_DRV VDD_DRV pfet L=0.55U W=10U AS=2.1P AD=2.1P PS=10.42U
+ PD=10.42U
* device instance $566 r0 *1 407.125,440.17 pfet
M$566 VDD_DRV x2_n5 OUT VDD_DRV pfet L=0.55U W=10U AS=2.1P AD=2.1P PS=10.42U
+ PD=10.42U
* device instance $567 r0 *1 408.095,440.17 pfet
M$567 OUT x2_n5 VDD_DRV VDD_DRV pfet L=0.55U W=10U AS=2.1P AD=2.1P PS=10.42U
+ PD=10.42U
* device instance $568 r0 *1 409.065,440.17 pfet
M$568 VDD_DRV x2_n5 OUT VDD_DRV pfet L=0.55U W=10U AS=2.1P AD=2.1P PS=10.42U
+ PD=10.42U
* device instance $569 r0 *1 410.035,440.17 pfet
M$569 OUT x2_n5 VDD_DRV VDD_DRV pfet L=0.55U W=10U AS=2.1P AD=2.1P PS=10.42U
+ PD=10.42U
* device instance $570 r0 *1 411.005,440.17 pfet
M$570 VDD_DRV x2_n5 OUT VDD_DRV pfet L=0.55U W=10U AS=2.1P AD=2.1P PS=10.42U
+ PD=10.42U
* device instance $571 r0 *1 411.975,440.17 pfet
M$571 OUT x2_n5 VDD_DRV VDD_DRV pfet L=0.55U W=10U AS=2.1P AD=2.1P PS=10.42U
+ PD=10.42U
* device instance $572 r0 *1 412.945,440.17 pfet
M$572 VDD_DRV x2_n5 OUT VDD_DRV pfet L=0.55U W=10U AS=2.1P AD=2.1P PS=10.42U
+ PD=10.42U
* device instance $573 r0 *1 413.915,440.17 pfet
M$573 OUT x2_n5 VDD_DRV VDD_DRV pfet L=0.55U W=10U AS=2.1P AD=2.1P PS=10.42U
+ PD=10.42U
* device instance $574 r0 *1 414.885,440.17 pfet
M$574 VDD_DRV x2_n5 OUT VDD_DRV pfet L=0.55U W=10U AS=2.1P AD=2.1P PS=10.42U
+ PD=10.42U
* device instance $575 r0 *1 415.855,440.17 pfet
M$575 OUT x2_n5 VDD_DRV VDD_DRV pfet L=0.55U W=10U AS=2.1P AD=2.1P PS=10.42U
+ PD=10.42U
* device instance $576 r0 *1 416.825,440.17 pfet
M$576 VDD_DRV x2_n5 OUT VDD_DRV pfet L=0.55U W=10U AS=2.1P AD=2.1P PS=10.42U
+ PD=10.42U
* device instance $577 r0 *1 417.795,440.17 pfet
M$577 OUT x2_n5 VDD_DRV VDD_DRV pfet L=0.55U W=10U AS=2.1P AD=2.1P PS=10.42U
+ PD=10.42U
* device instance $578 r0 *1 418.765,440.17 pfet
M$578 VDD_DRV x2_n5 OUT VDD_DRV pfet L=0.55U W=10U AS=2.1P AD=2.1P PS=10.42U
+ PD=10.42U
* device instance $579 r0 *1 419.735,440.17 pfet
M$579 OUT x2_n5 VDD_DRV VDD_DRV pfet L=0.55U W=10U AS=2.1P AD=2.1P PS=10.42U
+ PD=10.42U
* device instance $580 r0 *1 420.705,440.17 pfet
M$580 VDD_DRV x2_n5 OUT VDD_DRV pfet L=0.55U W=10U AS=2.1P AD=2.1P PS=10.42U
+ PD=10.42U
* device instance $581 r0 *1 421.675,440.17 pfet
M$581 OUT x2_n5 VDD_DRV VDD_DRV pfet L=0.55U W=10U AS=2.1P AD=2.1P PS=10.42U
+ PD=10.42U
* device instance $582 r0 *1 422.645,440.17 pfet
M$582 VDD_DRV x2_n5 OUT VDD_DRV pfet L=0.55U W=10U AS=2.1P AD=2.1P PS=10.42U
+ PD=10.42U
* device instance $583 r0 *1 423.615,440.17 pfet
M$583 OUT x2_n5 VDD_DRV VDD_DRV pfet L=0.55U W=10U AS=2.1P AD=2.1P PS=10.42U
+ PD=10.42U
* device instance $584 r0 *1 364.445,440.17 pfet
M$584 VDD_DRV x2_n5 OUT VDD_DRV pfet L=0.55U W=10U AS=2.1P AD=2.1P PS=10.42U
+ PD=10.42U
* device instance $585 r0 *1 303.335,440.17 pfet
M$585 OUT x2_n5 VDD_DRV VDD_DRV pfet L=0.55U W=10U AS=2.1P AD=2.1P PS=10.42U
+ PD=10.42U
* device instance $586 r0 *1 304.305,440.17 pfet
M$586 VDD_DRV x2_n5 OUT VDD_DRV pfet L=0.55U W=10U AS=2.1P AD=2.1P PS=10.42U
+ PD=10.42U
* device instance $587 r0 *1 305.275,440.17 pfet
M$587 OUT x2_n5 VDD_DRV VDD_DRV pfet L=0.55U W=10U AS=2.1P AD=2.1P PS=10.42U
+ PD=10.42U
* device instance $588 r0 *1 306.245,440.17 pfet
M$588 VDD_DRV x2_n5 OUT VDD_DRV pfet L=0.55U W=10U AS=2.1P AD=2.1P PS=10.42U
+ PD=10.42U
* device instance $589 r0 *1 307.215,440.17 pfet
M$589 OUT x2_n5 VDD_DRV VDD_DRV pfet L=0.55U W=10U AS=2.1P AD=2.1P PS=10.42U
+ PD=10.42U
* device instance $590 r0 *1 308.185,440.17 pfet
M$590 VDD_DRV x2_n5 OUT VDD_DRV pfet L=0.55U W=10U AS=2.1P AD=2.1P PS=10.42U
+ PD=10.42U
* device instance $591 r0 *1 309.155,440.17 pfet
M$591 OUT x2_n5 VDD_DRV VDD_DRV pfet L=0.55U W=10U AS=2.1P AD=2.1P PS=10.42U
+ PD=10.42U
* device instance $592 r0 *1 310.125,440.17 pfet
M$592 VDD_DRV x2_n5 OUT VDD_DRV pfet L=0.55U W=10U AS=2.1P AD=2.1P PS=10.42U
+ PD=10.42U
* device instance $593 r0 *1 311.095,440.17 pfet
M$593 OUT x2_n5 VDD_DRV VDD_DRV pfet L=0.55U W=10U AS=2.1P AD=2.1P PS=10.42U
+ PD=10.42U
* device instance $594 r0 *1 312.065,440.17 pfet
M$594 VDD_DRV x2_n5 OUT VDD_DRV pfet L=0.55U W=10U AS=2.1P AD=2.1P PS=10.42U
+ PD=10.42U
* device instance $595 r0 *1 313.035,440.17 pfet
M$595 OUT x2_n5 VDD_DRV VDD_DRV pfet L=0.55U W=10U AS=2.1P AD=2.1P PS=10.42U
+ PD=10.42U
* device instance $596 r0 *1 314.005,440.17 pfet
M$596 VDD_DRV x2_n5 OUT VDD_DRV pfet L=0.55U W=10U AS=2.1P AD=2.1P PS=10.42U
+ PD=10.42U
* device instance $597 r0 *1 314.975,440.17 pfet
M$597 OUT x2_n5 VDD_DRV VDD_DRV pfet L=0.55U W=10U AS=2.1P AD=2.1P PS=10.42U
+ PD=10.42U
* device instance $598 r0 *1 315.945,440.17 pfet
M$598 VDD_DRV x2_n5 OUT VDD_DRV pfet L=0.55U W=10U AS=2.1P AD=2.1P PS=10.42U
+ PD=10.42U
* device instance $599 r0 *1 316.915,440.17 pfet
M$599 OUT x2_n5 VDD_DRV VDD_DRV pfet L=0.55U W=10U AS=2.1P AD=2.1P PS=10.42U
+ PD=10.42U
* device instance $600 r0 *1 317.885,440.17 pfet
M$600 VDD_DRV x2_n5 OUT VDD_DRV pfet L=0.55U W=10U AS=2.1P AD=2.1P PS=10.42U
+ PD=10.42U
* device instance $601 r0 *1 318.855,440.17 pfet
M$601 OUT x2_n5 VDD_DRV VDD_DRV pfet L=0.55U W=10U AS=2.1P AD=2.1P PS=10.42U
+ PD=10.42U
* device instance $602 r0 *1 319.825,440.17 pfet
M$602 VDD_DRV x2_n5 OUT VDD_DRV pfet L=0.55U W=10U AS=2.1P AD=2.1P PS=10.42U
+ PD=10.42U
* device instance $603 r0 *1 320.795,440.17 pfet
M$603 OUT x2_n5 VDD_DRV VDD_DRV pfet L=0.55U W=10U AS=2.1P AD=2.1P PS=10.42U
+ PD=10.42U
* device instance $604 r0 *1 321.765,440.17 pfet
M$604 VDD_DRV x2_n5 OUT VDD_DRV pfet L=0.55U W=10U AS=2.1P AD=2.1P PS=10.42U
+ PD=10.42U
* device instance $605 r0 *1 322.735,440.17 pfet
M$605 OUT x2_n5 VDD_DRV VDD_DRV pfet L=0.55U W=10U AS=2.1P AD=2.1P PS=10.42U
+ PD=10.42U
* device instance $606 r0 *1 323.705,440.17 pfet
M$606 VDD_DRV x2_n5 OUT VDD_DRV pfet L=0.55U W=10U AS=2.1P AD=2.1P PS=10.42U
+ PD=10.42U
* device instance $607 r0 *1 324.675,440.17 pfet
M$607 OUT x2_n5 VDD_DRV VDD_DRV pfet L=0.55U W=10U AS=2.1P AD=2.1P PS=10.42U
+ PD=10.42U
* device instance $608 r0 *1 325.645,440.17 pfet
M$608 VDD_DRV x2_n5 OUT VDD_DRV pfet L=0.55U W=10U AS=2.1P AD=2.1P PS=10.42U
+ PD=10.42U
* device instance $609 r0 *1 326.615,440.17 pfet
M$609 OUT x2_n5 VDD_DRV VDD_DRV pfet L=0.55U W=10U AS=2.1P AD=2.1P PS=10.42U
+ PD=10.42U
* device instance $610 r0 *1 327.585,440.17 pfet
M$610 VDD_DRV x2_n5 OUT VDD_DRV pfet L=0.55U W=10U AS=2.1P AD=2.1P PS=10.42U
+ PD=10.42U
* device instance $611 r0 *1 328.555,440.17 pfet
M$611 OUT x2_n5 VDD_DRV VDD_DRV pfet L=0.55U W=10U AS=2.1P AD=2.1P PS=10.42U
+ PD=10.42U
* device instance $612 r0 *1 329.525,440.17 pfet
M$612 VDD_DRV x2_n5 OUT VDD_DRV pfet L=0.55U W=10U AS=2.1P AD=2.1P PS=10.42U
+ PD=10.42U
* device instance $613 r0 *1 330.495,440.17 pfet
M$613 OUT x2_n5 VDD_DRV VDD_DRV pfet L=0.55U W=10U AS=2.1P AD=2.1P PS=10.42U
+ PD=10.42U
* device instance $614 r0 *1 331.465,440.17 pfet
M$614 VDD_DRV x2_n5 OUT VDD_DRV pfet L=0.55U W=10U AS=2.1P AD=2.1P PS=10.42U
+ PD=10.42U
* device instance $615 r0 *1 332.435,440.17 pfet
M$615 OUT x2_n5 VDD_DRV VDD_DRV pfet L=0.55U W=10U AS=2.1P AD=2.1P PS=10.42U
+ PD=10.42U
* device instance $616 r0 *1 333.405,440.17 pfet
M$616 VDD_DRV x2_n5 OUT VDD_DRV pfet L=0.55U W=10U AS=2.1P AD=2.1P PS=10.42U
+ PD=10.42U
* device instance $617 r0 *1 334.375,440.17 pfet
M$617 OUT x2_n5 VDD_DRV VDD_DRV pfet L=0.55U W=10U AS=2.1P AD=2.1P PS=10.42U
+ PD=10.42U
* device instance $618 r0 *1 335.345,440.17 pfet
M$618 VDD_DRV x2_n5 OUT VDD_DRV pfet L=0.55U W=10U AS=2.1P AD=2.1P PS=10.42U
+ PD=10.42U
* device instance $619 r0 *1 336.315,440.17 pfet
M$619 OUT x2_n5 VDD_DRV VDD_DRV pfet L=0.55U W=10U AS=2.1P AD=2.1P PS=10.42U
+ PD=10.42U
* device instance $620 r0 *1 337.285,440.17 pfet
M$620 VDD_DRV x2_n5 OUT VDD_DRV pfet L=0.55U W=10U AS=2.1P AD=2.1P PS=10.42U
+ PD=10.42U
* device instance $621 r0 *1 338.255,440.17 pfet
M$621 OUT x2_n5 VDD_DRV VDD_DRV pfet L=0.55U W=10U AS=2.1P AD=2.1P PS=10.42U
+ PD=10.42U
* device instance $622 r0 *1 339.225,440.17 pfet
M$622 VDD_DRV x2_n5 OUT VDD_DRV pfet L=0.55U W=10U AS=2.1P AD=2.1P PS=10.42U
+ PD=10.42U
* device instance $623 r0 *1 340.195,440.17 pfet
M$623 OUT x2_n5 VDD_DRV VDD_DRV pfet L=0.55U W=10U AS=2.1P AD=2.1P PS=10.42U
+ PD=10.42U
* device instance $624 r0 *1 341.165,440.17 pfet
M$624 VDD_DRV x2_n5 OUT VDD_DRV pfet L=0.55U W=10U AS=2.1P AD=2.1P PS=10.42U
+ PD=10.42U
* device instance $625 r0 *1 342.135,440.17 pfet
M$625 OUT x2_n5 VDD_DRV VDD_DRV pfet L=0.55U W=10U AS=2.1P AD=2.1P PS=10.42U
+ PD=10.42U
* device instance $626 r0 *1 343.105,440.17 pfet
M$626 VDD_DRV x2_n5 OUT VDD_DRV pfet L=0.55U W=10U AS=2.1P AD=2.1P PS=10.42U
+ PD=10.42U
* device instance $627 r0 *1 344.075,440.17 pfet
M$627 OUT x2_n5 VDD_DRV VDD_DRV pfet L=0.55U W=10U AS=2.1P AD=2.1P PS=10.42U
+ PD=10.42U
* device instance $628 r0 *1 345.045,440.17 pfet
M$628 VDD_DRV x2_n5 OUT VDD_DRV pfet L=0.55U W=10U AS=2.1P AD=2.1P PS=10.42U
+ PD=10.42U
* device instance $629 r0 *1 346.015,440.17 pfet
M$629 OUT x2_n5 VDD_DRV VDD_DRV pfet L=0.55U W=10U AS=2.1P AD=2.1P PS=10.42U
+ PD=10.42U
* device instance $630 r0 *1 346.985,440.17 pfet
M$630 VDD_DRV x2_n5 OUT VDD_DRV pfet L=0.55U W=10U AS=2.1P AD=2.1P PS=10.42U
+ PD=10.42U
* device instance $631 r0 *1 347.955,440.17 pfet
M$631 OUT x2_n5 VDD_DRV VDD_DRV pfet L=0.55U W=10U AS=2.1P AD=2.1P PS=10.42U
+ PD=10.42U
* device instance $632 r0 *1 348.925,440.17 pfet
M$632 VDD_DRV x2_n5 OUT VDD_DRV pfet L=0.55U W=10U AS=2.1P AD=2.1P PS=10.42U
+ PD=10.42U
* device instance $633 r0 *1 349.895,440.17 pfet
M$633 OUT x2_n5 VDD_DRV VDD_DRV pfet L=0.55U W=10U AS=2.1P AD=2.1P PS=10.42U
+ PD=10.42U
* device instance $634 r0 *1 350.865,440.17 pfet
M$634 VDD_DRV x2_n5 OUT VDD_DRV pfet L=0.55U W=10U AS=2.1P AD=2.1P PS=10.42U
+ PD=10.42U
* device instance $635 r0 *1 351.835,440.17 pfet
M$635 OUT x2_n5 VDD_DRV VDD_DRV pfet L=0.55U W=10U AS=2.1P AD=2.1P PS=10.42U
+ PD=10.42U
* device instance $636 r0 *1 352.805,440.17 pfet
M$636 VDD_DRV x2_n5 OUT VDD_DRV pfet L=0.55U W=10U AS=2.1P AD=2.1P PS=10.42U
+ PD=10.42U
* device instance $637 r0 *1 353.775,440.17 pfet
M$637 OUT x2_n5 VDD_DRV VDD_DRV pfet L=0.55U W=10U AS=2.1P AD=2.1P PS=10.42U
+ PD=10.42U
* device instance $638 r0 *1 354.745,440.17 pfet
M$638 VDD_DRV x2_n5 OUT VDD_DRV pfet L=0.55U W=10U AS=2.1P AD=2.1P PS=10.42U
+ PD=10.42U
* device instance $639 r0 *1 355.715,440.17 pfet
M$639 OUT x2_n5 VDD_DRV VDD_DRV pfet L=0.55U W=10U AS=2.1P AD=2.1P PS=10.42U
+ PD=10.42U
* device instance $640 r0 *1 356.685,440.17 pfet
M$640 VDD_DRV x2_n5 OUT VDD_DRV pfet L=0.55U W=10U AS=2.1P AD=2.1P PS=10.42U
+ PD=10.42U
* device instance $641 r0 *1 357.655,440.17 pfet
M$641 OUT x2_n5 VDD_DRV VDD_DRV pfet L=0.55U W=10U AS=2.1P AD=2.1P PS=10.42U
+ PD=10.42U
* device instance $642 r0 *1 358.625,440.17 pfet
M$642 VDD_DRV x2_n5 OUT VDD_DRV pfet L=0.55U W=10U AS=2.1P AD=2.1P PS=10.42U
+ PD=10.42U
* device instance $643 r0 *1 359.595,440.17 pfet
M$643 OUT x2_n5 VDD_DRV VDD_DRV pfet L=0.55U W=10U AS=2.1P AD=2.1P PS=10.42U
+ PD=10.42U
* device instance $644 r0 *1 360.565,440.17 pfet
M$644 VDD_DRV x2_n5 OUT VDD_DRV pfet L=0.55U W=10U AS=2.1P AD=2.1P PS=10.42U
+ PD=10.42U
* device instance $645 r0 *1 361.535,440.17 pfet
M$645 OUT x2_n5 VDD_DRV VDD_DRV pfet L=0.55U W=10U AS=2.1P AD=2.1P PS=10.42U
+ PD=10.42U
* device instance $646 r0 *1 362.505,440.17 pfet
M$646 VDD_DRV x2_n5 OUT VDD_DRV pfet L=0.55U W=10U AS=2.1P AD=2.1P PS=10.42U
+ PD=10.42U
* device instance $647 r0 *1 363.475,440.17 pfet
M$647 OUT x2_n5 VDD_DRV VDD_DRV pfet L=0.55U W=10U AS=2.1P AD=2.1P PS=10.42U
+ PD=10.42U
* device instance $648 r0 *1 244.165,440.17 pfet
M$648 VDD_DRV x2_n5 OUT VDD_DRV pfet L=0.55U W=10U AS=2.1P AD=2.1P PS=10.42U
+ PD=10.42U
* device instance $649 r0 *1 245.135,440.17 pfet
M$649 OUT x2_n5 VDD_DRV VDD_DRV pfet L=0.55U W=10U AS=2.1P AD=2.1P PS=10.42U
+ PD=10.42U
* device instance $650 r0 *1 246.105,440.17 pfet
M$650 VDD_DRV x2_n5 OUT VDD_DRV pfet L=0.55U W=10U AS=2.1P AD=2.1P PS=10.42U
+ PD=10.42U
* device instance $651 r0 *1 247.075,440.17 pfet
M$651 OUT x2_n5 VDD_DRV VDD_DRV pfet L=0.55U W=10U AS=2.1P AD=2.1P PS=10.42U
+ PD=10.42U
* device instance $652 r0 *1 248.045,440.17 pfet
M$652 VDD_DRV x2_n5 OUT VDD_DRV pfet L=0.55U W=10U AS=2.1P AD=2.1P PS=10.42U
+ PD=10.42U
* device instance $653 r0 *1 249.015,440.17 pfet
M$653 OUT x2_n5 VDD_DRV VDD_DRV pfet L=0.55U W=10U AS=2.1P AD=2.1P PS=10.42U
+ PD=10.42U
* device instance $654 r0 *1 249.985,440.17 pfet
M$654 VDD_DRV x2_n5 OUT VDD_DRV pfet L=0.55U W=10U AS=2.1P AD=2.1P PS=10.42U
+ PD=10.42U
* device instance $655 r0 *1 250.955,440.17 pfet
M$655 OUT x2_n5 VDD_DRV VDD_DRV pfet L=0.55U W=10U AS=2.1P AD=2.1P PS=10.42U
+ PD=10.42U
* device instance $656 r0 *1 251.925,440.17 pfet
M$656 VDD_DRV x2_n5 OUT VDD_DRV pfet L=0.55U W=10U AS=2.1P AD=2.1P PS=10.42U
+ PD=10.42U
* device instance $657 r0 *1 252.895,440.17 pfet
M$657 OUT x2_n5 VDD_DRV VDD_DRV pfet L=0.55U W=10U AS=2.1P AD=2.1P PS=10.42U
+ PD=10.42U
* device instance $658 r0 *1 253.865,440.17 pfet
M$658 VDD_DRV x2_n5 OUT VDD_DRV pfet L=0.55U W=10U AS=2.1P AD=2.1P PS=10.42U
+ PD=10.42U
* device instance $659 r0 *1 254.835,440.17 pfet
M$659 OUT x2_n5 VDD_DRV VDD_DRV pfet L=0.55U W=10U AS=2.1P AD=2.1P PS=10.42U
+ PD=10.42U
* device instance $660 r0 *1 255.805,440.17 pfet
M$660 VDD_DRV x2_n5 OUT VDD_DRV pfet L=0.55U W=10U AS=2.1P AD=2.1P PS=10.42U
+ PD=10.42U
* device instance $661 r0 *1 256.775,440.17 pfet
M$661 OUT x2_n5 VDD_DRV VDD_DRV pfet L=0.55U W=10U AS=2.1P AD=2.1P PS=10.42U
+ PD=10.42U
* device instance $662 r0 *1 257.745,440.17 pfet
M$662 VDD_DRV x2_n5 OUT VDD_DRV pfet L=0.55U W=10U AS=2.1P AD=2.1P PS=10.42U
+ PD=10.42U
* device instance $663 r0 *1 258.715,440.17 pfet
M$663 OUT x2_n5 VDD_DRV VDD_DRV pfet L=0.55U W=10U AS=2.1P AD=2.1P PS=10.42U
+ PD=10.42U
* device instance $664 r0 *1 259.685,440.17 pfet
M$664 VDD_DRV x2_n5 OUT VDD_DRV pfet L=0.55U W=10U AS=2.1P AD=2.1P PS=10.42U
+ PD=10.42U
* device instance $665 r0 *1 260.655,440.17 pfet
M$665 OUT x2_n5 VDD_DRV VDD_DRV pfet L=0.55U W=10U AS=2.1P AD=2.1P PS=10.42U
+ PD=10.42U
* device instance $666 r0 *1 261.625,440.17 pfet
M$666 VDD_DRV x2_n5 OUT VDD_DRV pfet L=0.55U W=10U AS=2.1P AD=2.1P PS=10.42U
+ PD=10.42U
* device instance $667 r0 *1 262.595,440.17 pfet
M$667 OUT x2_n5 VDD_DRV VDD_DRV pfet L=0.55U W=10U AS=2.1P AD=2.1P PS=10.42U
+ PD=10.42U
* device instance $668 r0 *1 263.565,440.17 pfet
M$668 VDD_DRV x2_n5 OUT VDD_DRV pfet L=0.55U W=10U AS=2.1P AD=2.1P PS=10.42U
+ PD=10.42U
* device instance $669 r0 *1 264.535,440.17 pfet
M$669 OUT x2_n5 VDD_DRV VDD_DRV pfet L=0.55U W=10U AS=2.1P AD=2.1P PS=10.42U
+ PD=10.42U
* device instance $670 r0 *1 265.505,440.17 pfet
M$670 VDD_DRV x2_n5 OUT VDD_DRV pfet L=0.55U W=10U AS=2.1P AD=2.1P PS=10.42U
+ PD=10.42U
* device instance $671 r0 *1 266.475,440.17 pfet
M$671 OUT x2_n5 VDD_DRV VDD_DRV pfet L=0.55U W=10U AS=2.1P AD=2.1P PS=10.42U
+ PD=10.42U
* device instance $672 r0 *1 267.445,440.17 pfet
M$672 VDD_DRV x2_n5 OUT VDD_DRV pfet L=0.55U W=10U AS=2.1P AD=2.1P PS=10.42U
+ PD=10.42U
* device instance $673 r0 *1 268.415,440.17 pfet
M$673 OUT x2_n5 VDD_DRV VDD_DRV pfet L=0.55U W=10U AS=2.1P AD=2.1P PS=10.42U
+ PD=10.42U
* device instance $674 r0 *1 269.385,440.17 pfet
M$674 VDD_DRV x2_n5 OUT VDD_DRV pfet L=0.55U W=10U AS=2.1P AD=2.1P PS=10.42U
+ PD=10.42U
* device instance $675 r0 *1 270.355,440.17 pfet
M$675 OUT x2_n5 VDD_DRV VDD_DRV pfet L=0.55U W=10U AS=2.1P AD=2.1P PS=10.42U
+ PD=10.42U
* device instance $676 r0 *1 271.325,440.17 pfet
M$676 VDD_DRV x2_n5 OUT VDD_DRV pfet L=0.55U W=10U AS=2.1P AD=2.1P PS=10.42U
+ PD=10.42U
* device instance $677 r0 *1 272.295,440.17 pfet
M$677 OUT x2_n5 VDD_DRV VDD_DRV pfet L=0.55U W=10U AS=2.1P AD=2.1P PS=10.42U
+ PD=10.42U
* device instance $678 r0 *1 273.265,440.17 pfet
M$678 VDD_DRV x2_n5 OUT VDD_DRV pfet L=0.55U W=10U AS=2.1P AD=2.1P PS=10.42U
+ PD=10.42U
* device instance $679 r0 *1 274.235,440.17 pfet
M$679 OUT x2_n5 VDD_DRV VDD_DRV pfet L=0.55U W=10U AS=2.1P AD=2.1P PS=10.42U
+ PD=10.42U
* device instance $680 r0 *1 275.205,440.17 pfet
M$680 VDD_DRV x2_n5 OUT VDD_DRV pfet L=0.55U W=10U AS=2.1P AD=2.1P PS=10.42U
+ PD=10.42U
* device instance $681 r0 *1 276.175,440.17 pfet
M$681 OUT x2_n5 VDD_DRV VDD_DRV pfet L=0.55U W=10U AS=2.1P AD=2.1P PS=10.42U
+ PD=10.42U
* device instance $682 r0 *1 277.145,440.17 pfet
M$682 VDD_DRV x2_n5 OUT VDD_DRV pfet L=0.55U W=10U AS=2.1P AD=2.1P PS=10.42U
+ PD=10.42U
* device instance $683 r0 *1 278.115,440.17 pfet
M$683 OUT x2_n5 VDD_DRV VDD_DRV pfet L=0.55U W=10U AS=2.1P AD=2.1P PS=10.42U
+ PD=10.42U
* device instance $684 r0 *1 279.085,440.17 pfet
M$684 VDD_DRV x2_n5 OUT VDD_DRV pfet L=0.55U W=10U AS=2.1P AD=2.1P PS=10.42U
+ PD=10.42U
* device instance $685 r0 *1 280.055,440.17 pfet
M$685 OUT x2_n5 VDD_DRV VDD_DRV pfet L=0.55U W=10U AS=2.1P AD=2.1P PS=10.42U
+ PD=10.42U
* device instance $686 r0 *1 281.025,440.17 pfet
M$686 VDD_DRV x2_n5 OUT VDD_DRV pfet L=0.55U W=10U AS=2.1P AD=2.1P PS=10.42U
+ PD=10.42U
* device instance $687 r0 *1 281.995,440.17 pfet
M$687 OUT x2_n5 VDD_DRV VDD_DRV pfet L=0.55U W=10U AS=2.1P AD=2.1P PS=10.42U
+ PD=10.42U
* device instance $688 r0 *1 282.965,440.17 pfet
M$688 VDD_DRV x2_n5 OUT VDD_DRV pfet L=0.55U W=10U AS=2.1P AD=2.1P PS=10.42U
+ PD=10.42U
* device instance $689 r0 *1 283.935,440.17 pfet
M$689 OUT x2_n5 VDD_DRV VDD_DRV pfet L=0.55U W=10U AS=2.1P AD=2.1P PS=10.42U
+ PD=10.42U
* device instance $690 r0 *1 284.905,440.17 pfet
M$690 VDD_DRV x2_n5 OUT VDD_DRV pfet L=0.55U W=10U AS=2.1P AD=2.1P PS=10.42U
+ PD=10.42U
* device instance $691 r0 *1 285.875,440.17 pfet
M$691 OUT x2_n5 VDD_DRV VDD_DRV pfet L=0.55U W=10U AS=2.1P AD=2.1P PS=10.42U
+ PD=10.42U
* device instance $692 r0 *1 286.845,440.17 pfet
M$692 VDD_DRV x2_n5 OUT VDD_DRV pfet L=0.55U W=10U AS=2.1P AD=2.1P PS=10.42U
+ PD=10.42U
* device instance $693 r0 *1 287.815,440.17 pfet
M$693 OUT x2_n5 VDD_DRV VDD_DRV pfet L=0.55U W=10U AS=2.1P AD=2.1P PS=10.42U
+ PD=10.42U
* device instance $694 r0 *1 288.785,440.17 pfet
M$694 VDD_DRV x2_n5 OUT VDD_DRV pfet L=0.55U W=10U AS=2.1P AD=2.1P PS=10.42U
+ PD=10.42U
* device instance $695 r0 *1 289.755,440.17 pfet
M$695 OUT x2_n5 VDD_DRV VDD_DRV pfet L=0.55U W=10U AS=2.1P AD=2.1P PS=10.42U
+ PD=10.42U
* device instance $696 r0 *1 290.725,440.17 pfet
M$696 VDD_DRV x2_n5 OUT VDD_DRV pfet L=0.55U W=10U AS=2.1P AD=2.1P PS=10.42U
+ PD=10.42U
* device instance $697 r0 *1 291.695,440.17 pfet
M$697 OUT x2_n5 VDD_DRV VDD_DRV pfet L=0.55U W=10U AS=2.1P AD=2.1P PS=10.42U
+ PD=10.42U
* device instance $698 r0 *1 292.665,440.17 pfet
M$698 VDD_DRV x2_n5 OUT VDD_DRV pfet L=0.55U W=10U AS=2.1P AD=2.1P PS=10.42U
+ PD=10.42U
* device instance $699 r0 *1 293.635,440.17 pfet
M$699 OUT x2_n5 VDD_DRV VDD_DRV pfet L=0.55U W=10U AS=2.1P AD=2.1P PS=10.42U
+ PD=10.42U
* device instance $700 r0 *1 294.605,440.17 pfet
M$700 VDD_DRV x2_n5 OUT VDD_DRV pfet L=0.55U W=10U AS=2.1P AD=2.1P PS=10.42U
+ PD=10.42U
* device instance $701 r0 *1 295.575,440.17 pfet
M$701 OUT x2_n5 VDD_DRV VDD_DRV pfet L=0.55U W=10U AS=2.1P AD=2.1P PS=10.42U
+ PD=10.42U
* device instance $702 r0 *1 296.545,440.17 pfet
M$702 VDD_DRV x2_n5 OUT VDD_DRV pfet L=0.55U W=10U AS=2.1P AD=2.1P PS=10.42U
+ PD=10.42U
* device instance $703 r0 *1 297.515,440.17 pfet
M$703 OUT x2_n5 VDD_DRV VDD_DRV pfet L=0.55U W=10U AS=2.1P AD=2.1P PS=10.42U
+ PD=10.42U
* device instance $704 r0 *1 298.485,440.17 pfet
M$704 VDD_DRV x2_n5 OUT VDD_DRV pfet L=0.55U W=10U AS=2.1P AD=2.1P PS=10.42U
+ PD=10.42U
* device instance $705 r0 *1 299.455,440.17 pfet
M$705 OUT x2_n5 VDD_DRV VDD_DRV pfet L=0.55U W=10U AS=2.1P AD=2.1P PS=10.42U
+ PD=10.42U
* device instance $706 r0 *1 300.425,440.17 pfet
M$706 VDD_DRV x2_n5 OUT VDD_DRV pfet L=0.55U W=10U AS=2.1P AD=2.1P PS=10.42U
+ PD=10.42U
* device instance $707 r0 *1 301.395,440.17 pfet
M$707 OUT x2_n5 VDD_DRV VDD_DRV pfet L=0.55U W=10U AS=2.1P AD=2.1P PS=10.42U
+ PD=10.42U
* device instance $708 r0 *1 302.365,440.17 pfet
M$708 VDD_DRV x2_n5 OUT VDD_DRV pfet L=0.55U W=10U AS=2.1P AD=2.1P PS=10.42U
+ PD=10.42U
* device instance $709 r0 *1 243.195,440.17 pfet
M$709 OUT x2_n5 VDD_DRV VDD_DRV pfet L=0.55U W=10U AS=2.1P AD=2.1P PS=10.42U
+ PD=10.42U
* device instance $710 r0 *1 182.085,440.17 pfet
M$710 VDD_DRV x2_n5 OUT VDD_DRV pfet L=0.55U W=10U AS=2.1P AD=2.1P PS=10.42U
+ PD=10.42U
* device instance $711 r0 *1 183.055,440.17 pfet
M$711 OUT x2_n5 VDD_DRV VDD_DRV pfet L=0.55U W=10U AS=2.1P AD=2.1P PS=10.42U
+ PD=10.42U
* device instance $712 r0 *1 184.025,440.17 pfet
M$712 VDD_DRV x2_n5 OUT VDD_DRV pfet L=0.55U W=10U AS=2.1P AD=2.1P PS=10.42U
+ PD=10.42U
* device instance $713 r0 *1 184.995,440.17 pfet
M$713 OUT x2_n5 VDD_DRV VDD_DRV pfet L=0.55U W=10U AS=2.1P AD=2.1P PS=10.42U
+ PD=10.42U
* device instance $714 r0 *1 185.965,440.17 pfet
M$714 VDD_DRV x2_n5 OUT VDD_DRV pfet L=0.55U W=10U AS=2.1P AD=2.1P PS=10.42U
+ PD=10.42U
* device instance $715 r0 *1 186.935,440.17 pfet
M$715 OUT x2_n5 VDD_DRV VDD_DRV pfet L=0.55U W=10U AS=2.1P AD=2.1P PS=10.42U
+ PD=10.42U
* device instance $716 r0 *1 187.905,440.17 pfet
M$716 VDD_DRV x2_n5 OUT VDD_DRV pfet L=0.55U W=10U AS=2.1P AD=2.1P PS=10.42U
+ PD=10.42U
* device instance $717 r0 *1 188.875,440.17 pfet
M$717 OUT x2_n5 VDD_DRV VDD_DRV pfet L=0.55U W=10U AS=2.1P AD=2.1P PS=10.42U
+ PD=10.42U
* device instance $718 r0 *1 189.845,440.17 pfet
M$718 VDD_DRV x2_n5 OUT VDD_DRV pfet L=0.55U W=10U AS=2.1P AD=2.1P PS=10.42U
+ PD=10.42U
* device instance $719 r0 *1 190.815,440.17 pfet
M$719 OUT x2_n5 VDD_DRV VDD_DRV pfet L=0.55U W=10U AS=2.1P AD=2.1P PS=10.42U
+ PD=10.42U
* device instance $720 r0 *1 191.785,440.17 pfet
M$720 VDD_DRV x2_n5 OUT VDD_DRV pfet L=0.55U W=10U AS=2.1P AD=2.1P PS=10.42U
+ PD=10.42U
* device instance $721 r0 *1 192.755,440.17 pfet
M$721 OUT x2_n5 VDD_DRV VDD_DRV pfet L=0.55U W=10U AS=2.1P AD=2.1P PS=10.42U
+ PD=10.42U
* device instance $722 r0 *1 193.725,440.17 pfet
M$722 VDD_DRV x2_n5 OUT VDD_DRV pfet L=0.55U W=10U AS=2.1P AD=2.1P PS=10.42U
+ PD=10.42U
* device instance $723 r0 *1 194.695,440.17 pfet
M$723 OUT x2_n5 VDD_DRV VDD_DRV pfet L=0.55U W=10U AS=2.1P AD=2.1P PS=10.42U
+ PD=10.42U
* device instance $724 r0 *1 195.665,440.17 pfet
M$724 VDD_DRV x2_n5 OUT VDD_DRV pfet L=0.55U W=10U AS=2.1P AD=2.1P PS=10.42U
+ PD=10.42U
* device instance $725 r0 *1 196.635,440.17 pfet
M$725 OUT x2_n5 VDD_DRV VDD_DRV pfet L=0.55U W=10U AS=2.1P AD=2.1P PS=10.42U
+ PD=10.42U
* device instance $726 r0 *1 197.605,440.17 pfet
M$726 VDD_DRV x2_n5 OUT VDD_DRV pfet L=0.55U W=10U AS=2.1P AD=2.1P PS=10.42U
+ PD=10.42U
* device instance $727 r0 *1 198.575,440.17 pfet
M$727 OUT x2_n5 VDD_DRV VDD_DRV pfet L=0.55U W=10U AS=2.1P AD=2.1P PS=10.42U
+ PD=10.42U
* device instance $728 r0 *1 199.545,440.17 pfet
M$728 VDD_DRV x2_n5 OUT VDD_DRV pfet L=0.55U W=10U AS=2.1P AD=2.1P PS=10.42U
+ PD=10.42U
* device instance $729 r0 *1 200.515,440.17 pfet
M$729 OUT x2_n5 VDD_DRV VDD_DRV pfet L=0.55U W=10U AS=2.1P AD=2.1P PS=10.42U
+ PD=10.42U
* device instance $730 r0 *1 201.485,440.17 pfet
M$730 VDD_DRV x2_n5 OUT VDD_DRV pfet L=0.55U W=10U AS=2.1P AD=2.1P PS=10.42U
+ PD=10.42U
* device instance $731 r0 *1 202.455,440.17 pfet
M$731 OUT x2_n5 VDD_DRV VDD_DRV pfet L=0.55U W=10U AS=2.1P AD=2.1P PS=10.42U
+ PD=10.42U
* device instance $732 r0 *1 203.425,440.17 pfet
M$732 VDD_DRV x2_n5 OUT VDD_DRV pfet L=0.55U W=10U AS=2.1P AD=2.1P PS=10.42U
+ PD=10.42U
* device instance $733 r0 *1 204.395,440.17 pfet
M$733 OUT x2_n5 VDD_DRV VDD_DRV pfet L=0.55U W=10U AS=2.1P AD=2.1P PS=10.42U
+ PD=10.42U
* device instance $734 r0 *1 205.365,440.17 pfet
M$734 VDD_DRV x2_n5 OUT VDD_DRV pfet L=0.55U W=10U AS=2.1P AD=2.1P PS=10.42U
+ PD=10.42U
* device instance $735 r0 *1 206.335,440.17 pfet
M$735 OUT x2_n5 VDD_DRV VDD_DRV pfet L=0.55U W=10U AS=2.1P AD=2.1P PS=10.42U
+ PD=10.42U
* device instance $736 r0 *1 207.305,440.17 pfet
M$736 VDD_DRV x2_n5 OUT VDD_DRV pfet L=0.55U W=10U AS=2.1P AD=2.1P PS=10.42U
+ PD=10.42U
* device instance $737 r0 *1 208.275,440.17 pfet
M$737 OUT x2_n5 VDD_DRV VDD_DRV pfet L=0.55U W=10U AS=2.1P AD=2.1P PS=10.42U
+ PD=10.42U
* device instance $738 r0 *1 209.245,440.17 pfet
M$738 VDD_DRV x2_n5 OUT VDD_DRV pfet L=0.55U W=10U AS=2.1P AD=2.1P PS=10.42U
+ PD=10.42U
* device instance $739 r0 *1 210.215,440.17 pfet
M$739 OUT x2_n5 VDD_DRV VDD_DRV pfet L=0.55U W=10U AS=2.1P AD=2.1P PS=10.42U
+ PD=10.42U
* device instance $740 r0 *1 211.185,440.17 pfet
M$740 VDD_DRV x2_n5 OUT VDD_DRV pfet L=0.55U W=10U AS=2.1P AD=2.1P PS=10.42U
+ PD=10.42U
* device instance $741 r0 *1 212.155,440.17 pfet
M$741 OUT x2_n5 VDD_DRV VDD_DRV pfet L=0.55U W=10U AS=2.1P AD=2.1P PS=10.42U
+ PD=10.42U
* device instance $742 r0 *1 213.125,440.17 pfet
M$742 VDD_DRV x2_n5 OUT VDD_DRV pfet L=0.55U W=10U AS=2.1P AD=2.1P PS=10.42U
+ PD=10.42U
* device instance $743 r0 *1 214.095,440.17 pfet
M$743 OUT x2_n5 VDD_DRV VDD_DRV pfet L=0.55U W=10U AS=2.1P AD=2.1P PS=10.42U
+ PD=10.42U
* device instance $744 r0 *1 215.065,440.17 pfet
M$744 VDD_DRV x2_n5 OUT VDD_DRV pfet L=0.55U W=10U AS=2.1P AD=2.1P PS=10.42U
+ PD=10.42U
* device instance $745 r0 *1 216.035,440.17 pfet
M$745 OUT x2_n5 VDD_DRV VDD_DRV pfet L=0.55U W=10U AS=2.1P AD=2.1P PS=10.42U
+ PD=10.42U
* device instance $746 r0 *1 217.005,440.17 pfet
M$746 VDD_DRV x2_n5 OUT VDD_DRV pfet L=0.55U W=10U AS=2.1P AD=2.1P PS=10.42U
+ PD=10.42U
* device instance $747 r0 *1 217.975,440.17 pfet
M$747 OUT x2_n5 VDD_DRV VDD_DRV pfet L=0.55U W=10U AS=2.1P AD=2.1P PS=10.42U
+ PD=10.42U
* device instance $748 r0 *1 218.945,440.17 pfet
M$748 VDD_DRV x2_n5 OUT VDD_DRV pfet L=0.55U W=10U AS=2.1P AD=2.1P PS=10.42U
+ PD=10.42U
* device instance $749 r0 *1 219.915,440.17 pfet
M$749 OUT x2_n5 VDD_DRV VDD_DRV pfet L=0.55U W=10U AS=2.1P AD=2.1P PS=10.42U
+ PD=10.42U
* device instance $750 r0 *1 220.885,440.17 pfet
M$750 VDD_DRV x2_n5 OUT VDD_DRV pfet L=0.55U W=10U AS=2.1P AD=2.1P PS=10.42U
+ PD=10.42U
* device instance $751 r0 *1 221.855,440.17 pfet
M$751 OUT x2_n5 VDD_DRV VDD_DRV pfet L=0.55U W=10U AS=2.1P AD=2.1P PS=10.42U
+ PD=10.42U
* device instance $752 r0 *1 222.825,440.17 pfet
M$752 VDD_DRV x2_n5 OUT VDD_DRV pfet L=0.55U W=10U AS=2.1P AD=2.1P PS=10.42U
+ PD=10.42U
* device instance $753 r0 *1 223.795,440.17 pfet
M$753 OUT x2_n5 VDD_DRV VDD_DRV pfet L=0.55U W=10U AS=2.1P AD=2.1P PS=10.42U
+ PD=10.42U
* device instance $754 r0 *1 224.765,440.17 pfet
M$754 VDD_DRV x2_n5 OUT VDD_DRV pfet L=0.55U W=10U AS=2.1P AD=2.1P PS=10.42U
+ PD=10.42U
* device instance $755 r0 *1 225.735,440.17 pfet
M$755 OUT x2_n5 VDD_DRV VDD_DRV pfet L=0.55U W=10U AS=2.1P AD=2.1P PS=10.42U
+ PD=10.42U
* device instance $756 r0 *1 226.705,440.17 pfet
M$756 VDD_DRV x2_n5 OUT VDD_DRV pfet L=0.55U W=10U AS=2.1P AD=2.1P PS=10.42U
+ PD=10.42U
* device instance $757 r0 *1 227.675,440.17 pfet
M$757 OUT x2_n5 VDD_DRV VDD_DRV pfet L=0.55U W=10U AS=2.1P AD=2.1P PS=10.42U
+ PD=10.42U
* device instance $758 r0 *1 228.645,440.17 pfet
M$758 VDD_DRV x2_n5 OUT VDD_DRV pfet L=0.55U W=10U AS=2.1P AD=2.1P PS=10.42U
+ PD=10.42U
* device instance $759 r0 *1 229.615,440.17 pfet
M$759 OUT x2_n5 VDD_DRV VDD_DRV pfet L=0.55U W=10U AS=2.1P AD=2.1P PS=10.42U
+ PD=10.42U
* device instance $760 r0 *1 230.585,440.17 pfet
M$760 VDD_DRV x2_n5 OUT VDD_DRV pfet L=0.55U W=10U AS=2.1P AD=2.1P PS=10.42U
+ PD=10.42U
* device instance $761 r0 *1 231.555,440.17 pfet
M$761 OUT x2_n5 VDD_DRV VDD_DRV pfet L=0.55U W=10U AS=2.1P AD=2.1P PS=10.42U
+ PD=10.42U
* device instance $762 r0 *1 232.525,440.17 pfet
M$762 VDD_DRV x2_n5 OUT VDD_DRV pfet L=0.55U W=10U AS=2.1P AD=2.1P PS=10.42U
+ PD=10.42U
* device instance $763 r0 *1 233.495,440.17 pfet
M$763 OUT x2_n5 VDD_DRV VDD_DRV pfet L=0.55U W=10U AS=2.1P AD=2.1P PS=10.42U
+ PD=10.42U
* device instance $764 r0 *1 234.465,440.17 pfet
M$764 VDD_DRV x2_n5 OUT VDD_DRV pfet L=0.55U W=10U AS=2.1P AD=2.1P PS=10.42U
+ PD=10.42U
* device instance $765 r0 *1 235.435,440.17 pfet
M$765 OUT x2_n5 VDD_DRV VDD_DRV pfet L=0.55U W=10U AS=2.1P AD=2.1P PS=10.42U
+ PD=10.42U
* device instance $766 r0 *1 236.405,440.17 pfet
M$766 VDD_DRV x2_n5 OUT VDD_DRV pfet L=0.55U W=10U AS=2.1P AD=2.1P PS=10.42U
+ PD=10.42U
* device instance $767 r0 *1 237.375,440.17 pfet
M$767 OUT x2_n5 VDD_DRV VDD_DRV pfet L=0.55U W=10U AS=2.1P AD=2.1P PS=10.42U
+ PD=10.42U
* device instance $768 r0 *1 238.345,440.17 pfet
M$768 VDD_DRV x2_n5 OUT VDD_DRV pfet L=0.55U W=10U AS=2.1P AD=2.1P PS=10.42U
+ PD=10.42U
* device instance $769 r0 *1 239.315,440.17 pfet
M$769 OUT x2_n5 VDD_DRV VDD_DRV pfet L=0.55U W=10U AS=2.1P AD=2.1P PS=10.42U
+ PD=10.42U
* device instance $770 r0 *1 240.285,440.17 pfet
M$770 VDD_DRV x2_n5 OUT VDD_DRV pfet L=0.55U W=10U AS=2.1P AD=2.1P PS=10.42U
+ PD=10.42U
* device instance $771 r0 *1 241.255,440.17 pfet
M$771 OUT x2_n5 VDD_DRV VDD_DRV pfet L=0.55U W=10U AS=2.1P AD=2.1P PS=10.42U
+ PD=10.42U
* device instance $772 r0 *1 242.225,440.17 pfet
M$772 VDD_DRV x2_n5 OUT VDD_DRV pfet L=0.55U W=10U AS=2.1P AD=2.1P PS=10.42U
+ PD=10.42U
* device instance $773 r0 *1 122.915,440.17 pfet
M$773 OUT x2_n5 VDD_DRV VDD_DRV pfet L=0.55U W=10U AS=2.1P AD=2.1P PS=10.42U
+ PD=10.42U
* device instance $774 r0 *1 123.885,440.17 pfet
M$774 VDD_DRV x2_n5 OUT VDD_DRV pfet L=0.55U W=10U AS=2.1P AD=2.1P PS=10.42U
+ PD=10.42U
* device instance $775 r0 *1 124.855,440.17 pfet
M$775 OUT x2_n5 VDD_DRV VDD_DRV pfet L=0.55U W=10U AS=2.1P AD=2.1P PS=10.42U
+ PD=10.42U
* device instance $776 r0 *1 125.825,440.17 pfet
M$776 VDD_DRV x2_n5 OUT VDD_DRV pfet L=0.55U W=10U AS=2.1P AD=2.1P PS=10.42U
+ PD=10.42U
* device instance $777 r0 *1 126.795,440.17 pfet
M$777 OUT x2_n5 VDD_DRV VDD_DRV pfet L=0.55U W=10U AS=2.1P AD=2.1P PS=10.42U
+ PD=10.42U
* device instance $778 r0 *1 127.765,440.17 pfet
M$778 VDD_DRV x2_n5 OUT VDD_DRV pfet L=0.55U W=10U AS=2.1P AD=2.1P PS=10.42U
+ PD=10.42U
* device instance $779 r0 *1 128.735,440.17 pfet
M$779 OUT x2_n5 VDD_DRV VDD_DRV pfet L=0.55U W=10U AS=2.1P AD=2.1P PS=10.42U
+ PD=10.42U
* device instance $780 r0 *1 129.705,440.17 pfet
M$780 VDD_DRV x2_n5 OUT VDD_DRV pfet L=0.55U W=10U AS=2.1P AD=2.1P PS=10.42U
+ PD=10.42U
* device instance $781 r0 *1 130.675,440.17 pfet
M$781 OUT x2_n5 VDD_DRV VDD_DRV pfet L=0.55U W=10U AS=2.1P AD=2.1P PS=10.42U
+ PD=10.42U
* device instance $782 r0 *1 131.645,440.17 pfet
M$782 VDD_DRV x2_n5 OUT VDD_DRV pfet L=0.55U W=10U AS=2.1P AD=2.1P PS=10.42U
+ PD=10.42U
* device instance $783 r0 *1 132.615,440.17 pfet
M$783 OUT x2_n5 VDD_DRV VDD_DRV pfet L=0.55U W=10U AS=2.1P AD=2.1P PS=10.42U
+ PD=10.42U
* device instance $784 r0 *1 133.585,440.17 pfet
M$784 VDD_DRV x2_n5 OUT VDD_DRV pfet L=0.55U W=10U AS=2.1P AD=2.1P PS=10.42U
+ PD=10.42U
* device instance $785 r0 *1 134.555,440.17 pfet
M$785 OUT x2_n5 VDD_DRV VDD_DRV pfet L=0.55U W=10U AS=2.1P AD=2.1P PS=10.42U
+ PD=10.42U
* device instance $786 r0 *1 135.525,440.17 pfet
M$786 VDD_DRV x2_n5 OUT VDD_DRV pfet L=0.55U W=10U AS=2.1P AD=2.1P PS=10.42U
+ PD=10.42U
* device instance $787 r0 *1 136.495,440.17 pfet
M$787 OUT x2_n5 VDD_DRV VDD_DRV pfet L=0.55U W=10U AS=2.1P AD=2.1P PS=10.42U
+ PD=10.42U
* device instance $788 r0 *1 137.465,440.17 pfet
M$788 VDD_DRV x2_n5 OUT VDD_DRV pfet L=0.55U W=10U AS=2.1P AD=2.1P PS=10.42U
+ PD=10.42U
* device instance $789 r0 *1 138.435,440.17 pfet
M$789 OUT x2_n5 VDD_DRV VDD_DRV pfet L=0.55U W=10U AS=2.1P AD=2.1P PS=10.42U
+ PD=10.42U
* device instance $790 r0 *1 139.405,440.17 pfet
M$790 VDD_DRV x2_n5 OUT VDD_DRV pfet L=0.55U W=10U AS=2.1P AD=2.1P PS=10.42U
+ PD=10.42U
* device instance $791 r0 *1 140.375,440.17 pfet
M$791 OUT x2_n5 VDD_DRV VDD_DRV pfet L=0.55U W=10U AS=2.1P AD=2.1P PS=10.42U
+ PD=10.42U
* device instance $792 r0 *1 141.345,440.17 pfet
M$792 VDD_DRV x2_n5 OUT VDD_DRV pfet L=0.55U W=10U AS=2.1P AD=2.1P PS=10.42U
+ PD=10.42U
* device instance $793 r0 *1 142.315,440.17 pfet
M$793 OUT x2_n5 VDD_DRV VDD_DRV pfet L=0.55U W=10U AS=2.1P AD=2.1P PS=10.42U
+ PD=10.42U
* device instance $794 r0 *1 143.285,440.17 pfet
M$794 VDD_DRV x2_n5 OUT VDD_DRV pfet L=0.55U W=10U AS=2.1P AD=2.1P PS=10.42U
+ PD=10.42U
* device instance $795 r0 *1 144.255,440.17 pfet
M$795 OUT x2_n5 VDD_DRV VDD_DRV pfet L=0.55U W=10U AS=2.1P AD=2.1P PS=10.42U
+ PD=10.42U
* device instance $796 r0 *1 145.225,440.17 pfet
M$796 VDD_DRV x2_n5 OUT VDD_DRV pfet L=0.55U W=10U AS=2.1P AD=2.1P PS=10.42U
+ PD=10.42U
* device instance $797 r0 *1 146.195,440.17 pfet
M$797 OUT x2_n5 VDD_DRV VDD_DRV pfet L=0.55U W=10U AS=2.1P AD=2.1P PS=10.42U
+ PD=10.42U
* device instance $798 r0 *1 147.165,440.17 pfet
M$798 VDD_DRV x2_n5 OUT VDD_DRV pfet L=0.55U W=10U AS=2.1P AD=2.1P PS=10.42U
+ PD=10.42U
* device instance $799 r0 *1 148.135,440.17 pfet
M$799 OUT x2_n5 VDD_DRV VDD_DRV pfet L=0.55U W=10U AS=2.1P AD=2.1P PS=10.42U
+ PD=10.42U
* device instance $800 r0 *1 149.105,440.17 pfet
M$800 VDD_DRV x2_n5 OUT VDD_DRV pfet L=0.55U W=10U AS=2.1P AD=2.1P PS=10.42U
+ PD=10.42U
* device instance $801 r0 *1 150.075,440.17 pfet
M$801 OUT x2_n5 VDD_DRV VDD_DRV pfet L=0.55U W=10U AS=2.1P AD=2.1P PS=10.42U
+ PD=10.42U
* device instance $802 r0 *1 151.045,440.17 pfet
M$802 VDD_DRV x2_n5 OUT VDD_DRV pfet L=0.55U W=10U AS=2.1P AD=2.1P PS=10.42U
+ PD=10.42U
* device instance $803 r0 *1 152.015,440.17 pfet
M$803 OUT x2_n5 VDD_DRV VDD_DRV pfet L=0.55U W=10U AS=2.1P AD=2.1P PS=10.42U
+ PD=10.42U
* device instance $804 r0 *1 152.985,440.17 pfet
M$804 VDD_DRV x2_n5 OUT VDD_DRV pfet L=0.55U W=10U AS=2.1P AD=2.1P PS=10.42U
+ PD=10.42U
* device instance $805 r0 *1 153.955,440.17 pfet
M$805 OUT x2_n5 VDD_DRV VDD_DRV pfet L=0.55U W=10U AS=2.1P AD=2.1P PS=10.42U
+ PD=10.42U
* device instance $806 r0 *1 154.925,440.17 pfet
M$806 VDD_DRV x2_n5 OUT VDD_DRV pfet L=0.55U W=10U AS=2.1P AD=2.1P PS=10.42U
+ PD=10.42U
* device instance $807 r0 *1 155.895,440.17 pfet
M$807 OUT x2_n5 VDD_DRV VDD_DRV pfet L=0.55U W=10U AS=2.1P AD=2.1P PS=10.42U
+ PD=10.42U
* device instance $808 r0 *1 156.865,440.17 pfet
M$808 VDD_DRV x2_n5 OUT VDD_DRV pfet L=0.55U W=10U AS=2.1P AD=2.1P PS=10.42U
+ PD=10.42U
* device instance $809 r0 *1 157.835,440.17 pfet
M$809 OUT x2_n5 VDD_DRV VDD_DRV pfet L=0.55U W=10U AS=2.1P AD=2.1P PS=10.42U
+ PD=10.42U
* device instance $810 r0 *1 158.805,440.17 pfet
M$810 VDD_DRV x2_n5 OUT VDD_DRV pfet L=0.55U W=10U AS=2.1P AD=2.1P PS=10.42U
+ PD=10.42U
* device instance $811 r0 *1 159.775,440.17 pfet
M$811 OUT x2_n5 VDD_DRV VDD_DRV pfet L=0.55U W=10U AS=2.1P AD=2.1P PS=10.42U
+ PD=10.42U
* device instance $812 r0 *1 160.745,440.17 pfet
M$812 VDD_DRV x2_n5 OUT VDD_DRV pfet L=0.55U W=10U AS=2.1P AD=2.1P PS=10.42U
+ PD=10.42U
* device instance $813 r0 *1 161.715,440.17 pfet
M$813 OUT x2_n5 VDD_DRV VDD_DRV pfet L=0.55U W=10U AS=2.1P AD=2.1P PS=10.42U
+ PD=10.42U
* device instance $814 r0 *1 162.685,440.17 pfet
M$814 VDD_DRV x2_n5 OUT VDD_DRV pfet L=0.55U W=10U AS=2.1P AD=2.1P PS=10.42U
+ PD=10.42U
* device instance $815 r0 *1 163.655,440.17 pfet
M$815 OUT x2_n5 VDD_DRV VDD_DRV pfet L=0.55U W=10U AS=2.1P AD=2.1P PS=10.42U
+ PD=10.42U
* device instance $816 r0 *1 164.625,440.17 pfet
M$816 VDD_DRV x2_n5 OUT VDD_DRV pfet L=0.55U W=10U AS=2.1P AD=2.1P PS=10.42U
+ PD=10.42U
* device instance $817 r0 *1 165.595,440.17 pfet
M$817 OUT x2_n5 VDD_DRV VDD_DRV pfet L=0.55U W=10U AS=2.1P AD=2.1P PS=10.42U
+ PD=10.42U
* device instance $818 r0 *1 166.565,440.17 pfet
M$818 VDD_DRV x2_n5 OUT VDD_DRV pfet L=0.55U W=10U AS=2.1P AD=2.1P PS=10.42U
+ PD=10.42U
* device instance $819 r0 *1 167.535,440.17 pfet
M$819 OUT x2_n5 VDD_DRV VDD_DRV pfet L=0.55U W=10U AS=2.1P AD=2.1P PS=10.42U
+ PD=10.42U
* device instance $820 r0 *1 168.505,440.17 pfet
M$820 VDD_DRV x2_n5 OUT VDD_DRV pfet L=0.55U W=10U AS=2.1P AD=2.1P PS=10.42U
+ PD=10.42U
* device instance $821 r0 *1 169.475,440.17 pfet
M$821 OUT x2_n5 VDD_DRV VDD_DRV pfet L=0.55U W=10U AS=2.1P AD=2.1P PS=10.42U
+ PD=10.42U
* device instance $822 r0 *1 170.445,440.17 pfet
M$822 VDD_DRV x2_n5 OUT VDD_DRV pfet L=0.55U W=10U AS=2.1P AD=2.1P PS=10.42U
+ PD=10.42U
* device instance $823 r0 *1 171.415,440.17 pfet
M$823 OUT x2_n5 VDD_DRV VDD_DRV pfet L=0.55U W=10U AS=2.1P AD=2.1P PS=10.42U
+ PD=10.42U
* device instance $824 r0 *1 172.385,440.17 pfet
M$824 VDD_DRV x2_n5 OUT VDD_DRV pfet L=0.55U W=10U AS=2.1P AD=2.1P PS=10.42U
+ PD=10.42U
* device instance $825 r0 *1 173.355,440.17 pfet
M$825 OUT x2_n5 VDD_DRV VDD_DRV pfet L=0.55U W=10U AS=2.1P AD=2.1P PS=10.42U
+ PD=10.42U
* device instance $826 r0 *1 174.325,440.17 pfet
M$826 VDD_DRV x2_n5 OUT VDD_DRV pfet L=0.55U W=10U AS=2.1P AD=2.1P PS=10.42U
+ PD=10.42U
* device instance $827 r0 *1 175.295,440.17 pfet
M$827 OUT x2_n5 VDD_DRV VDD_DRV pfet L=0.55U W=10U AS=2.1P AD=2.1P PS=10.42U
+ PD=10.42U
* device instance $828 r0 *1 176.265,440.17 pfet
M$828 VDD_DRV x2_n5 OUT VDD_DRV pfet L=0.55U W=10U AS=2.1P AD=2.1P PS=10.42U
+ PD=10.42U
* device instance $829 r0 *1 177.235,440.17 pfet
M$829 OUT x2_n5 VDD_DRV VDD_DRV pfet L=0.55U W=10U AS=2.1P AD=2.1P PS=10.42U
+ PD=10.42U
* device instance $830 r0 *1 178.205,440.17 pfet
M$830 VDD_DRV x2_n5 OUT VDD_DRV pfet L=0.55U W=10U AS=2.1P AD=2.1P PS=10.42U
+ PD=10.42U
* device instance $831 r0 *1 179.175,440.17 pfet
M$831 OUT x2_n5 VDD_DRV VDD_DRV pfet L=0.55U W=10U AS=2.1P AD=2.1P PS=10.42U
+ PD=10.42U
* device instance $832 r0 *1 180.145,440.17 pfet
M$832 VDD_DRV x2_n5 OUT VDD_DRV pfet L=0.55U W=10U AS=2.1P AD=2.1P PS=10.42U
+ PD=10.42U
* device instance $833 r0 *1 181.115,440.17 pfet
M$833 OUT x2_n5 VDD_DRV VDD_DRV pfet L=0.55U W=10U AS=2.1P AD=2.1P PS=10.42U
+ PD=10.42U
* device instance $834 r0 *1 121.945,440.17 pfet
M$834 VDD_DRV x2_n5 OUT VDD_DRV pfet L=0.55U W=10U AS=2.1P AD=2.1P PS=10.42U
+ PD=10.42U
* device instance $835 r0 *1 60.835,440.17 pfet
M$835 OUT x2_n5 VDD_DRV VDD_DRV pfet L=0.55U W=10U AS=2.1P AD=2.1P PS=10.42U
+ PD=10.42U
* device instance $836 r0 *1 61.805,440.17 pfet
M$836 VDD_DRV x2_n5 OUT VDD_DRV pfet L=0.55U W=10U AS=2.1P AD=2.1P PS=10.42U
+ PD=10.42U
* device instance $837 r0 *1 62.775,440.17 pfet
M$837 OUT x2_n5 VDD_DRV VDD_DRV pfet L=0.55U W=10U AS=2.1P AD=2.1P PS=10.42U
+ PD=10.42U
* device instance $838 r0 *1 63.745,440.17 pfet
M$838 VDD_DRV x2_n5 OUT VDD_DRV pfet L=0.55U W=10U AS=2.1P AD=2.1P PS=10.42U
+ PD=10.42U
* device instance $839 r0 *1 64.715,440.17 pfet
M$839 OUT x2_n5 VDD_DRV VDD_DRV pfet L=0.55U W=10U AS=2.1P AD=2.1P PS=10.42U
+ PD=10.42U
* device instance $840 r0 *1 65.685,440.17 pfet
M$840 VDD_DRV x2_n5 OUT VDD_DRV pfet L=0.55U W=10U AS=2.1P AD=2.1P PS=10.42U
+ PD=10.42U
* device instance $841 r0 *1 66.655,440.17 pfet
M$841 OUT x2_n5 VDD_DRV VDD_DRV pfet L=0.55U W=10U AS=2.1P AD=2.1P PS=10.42U
+ PD=10.42U
* device instance $842 r0 *1 67.625,440.17 pfet
M$842 VDD_DRV x2_n5 OUT VDD_DRV pfet L=0.55U W=10U AS=2.1P AD=2.1P PS=10.42U
+ PD=10.42U
* device instance $843 r0 *1 68.595,440.17 pfet
M$843 OUT x2_n5 VDD_DRV VDD_DRV pfet L=0.55U W=10U AS=2.1P AD=2.1P PS=10.42U
+ PD=10.42U
* device instance $844 r0 *1 69.565,440.17 pfet
M$844 VDD_DRV x2_n5 OUT VDD_DRV pfet L=0.55U W=10U AS=2.1P AD=2.1P PS=10.42U
+ PD=10.42U
* device instance $845 r0 *1 70.535,440.17 pfet
M$845 OUT x2_n5 VDD_DRV VDD_DRV pfet L=0.55U W=10U AS=2.1P AD=2.1P PS=10.42U
+ PD=10.42U
* device instance $846 r0 *1 71.505,440.17 pfet
M$846 VDD_DRV x2_n5 OUT VDD_DRV pfet L=0.55U W=10U AS=2.1P AD=2.1P PS=10.42U
+ PD=10.42U
* device instance $847 r0 *1 72.475,440.17 pfet
M$847 OUT x2_n5 VDD_DRV VDD_DRV pfet L=0.55U W=10U AS=2.1P AD=2.1P PS=10.42U
+ PD=10.42U
* device instance $848 r0 *1 73.445,440.17 pfet
M$848 VDD_DRV x2_n5 OUT VDD_DRV pfet L=0.55U W=10U AS=2.1P AD=2.1P PS=10.42U
+ PD=10.42U
* device instance $849 r0 *1 74.415,440.17 pfet
M$849 OUT x2_n5 VDD_DRV VDD_DRV pfet L=0.55U W=10U AS=2.1P AD=2.1P PS=10.42U
+ PD=10.42U
* device instance $850 r0 *1 75.385,440.17 pfet
M$850 VDD_DRV x2_n5 OUT VDD_DRV pfet L=0.55U W=10U AS=2.1P AD=2.1P PS=10.42U
+ PD=10.42U
* device instance $851 r0 *1 76.355,440.17 pfet
M$851 OUT x2_n5 VDD_DRV VDD_DRV pfet L=0.55U W=10U AS=2.1P AD=2.1P PS=10.42U
+ PD=10.42U
* device instance $852 r0 *1 77.325,440.17 pfet
M$852 VDD_DRV x2_n5 OUT VDD_DRV pfet L=0.55U W=10U AS=2.1P AD=2.1P PS=10.42U
+ PD=10.42U
* device instance $853 r0 *1 78.295,440.17 pfet
M$853 OUT x2_n5 VDD_DRV VDD_DRV pfet L=0.55U W=10U AS=2.1P AD=2.1P PS=10.42U
+ PD=10.42U
* device instance $854 r0 *1 79.265,440.17 pfet
M$854 VDD_DRV x2_n5 OUT VDD_DRV pfet L=0.55U W=10U AS=2.1P AD=2.1P PS=10.42U
+ PD=10.42U
* device instance $855 r0 *1 80.235,440.17 pfet
M$855 OUT x2_n5 VDD_DRV VDD_DRV pfet L=0.55U W=10U AS=2.1P AD=2.1P PS=10.42U
+ PD=10.42U
* device instance $856 r0 *1 81.205,440.17 pfet
M$856 VDD_DRV x2_n5 OUT VDD_DRV pfet L=0.55U W=10U AS=2.1P AD=2.1P PS=10.42U
+ PD=10.42U
* device instance $857 r0 *1 82.175,440.17 pfet
M$857 OUT x2_n5 VDD_DRV VDD_DRV pfet L=0.55U W=10U AS=2.1P AD=2.1P PS=10.42U
+ PD=10.42U
* device instance $858 r0 *1 83.145,440.17 pfet
M$858 VDD_DRV x2_n5 OUT VDD_DRV pfet L=0.55U W=10U AS=2.1P AD=2.1P PS=10.42U
+ PD=10.42U
* device instance $859 r0 *1 84.115,440.17 pfet
M$859 OUT x2_n5 VDD_DRV VDD_DRV pfet L=0.55U W=10U AS=2.1P AD=2.1P PS=10.42U
+ PD=10.42U
* device instance $860 r0 *1 85.085,440.17 pfet
M$860 VDD_DRV x2_n5 OUT VDD_DRV pfet L=0.55U W=10U AS=2.1P AD=2.1P PS=10.42U
+ PD=10.42U
* device instance $861 r0 *1 86.055,440.17 pfet
M$861 OUT x2_n5 VDD_DRV VDD_DRV pfet L=0.55U W=10U AS=2.1P AD=2.1P PS=10.42U
+ PD=10.42U
* device instance $862 r0 *1 87.025,440.17 pfet
M$862 VDD_DRV x2_n5 OUT VDD_DRV pfet L=0.55U W=10U AS=2.1P AD=2.1P PS=10.42U
+ PD=10.42U
* device instance $863 r0 *1 87.995,440.17 pfet
M$863 OUT x2_n5 VDD_DRV VDD_DRV pfet L=0.55U W=10U AS=2.1P AD=2.1P PS=10.42U
+ PD=10.42U
* device instance $864 r0 *1 88.965,440.17 pfet
M$864 VDD_DRV x2_n5 OUT VDD_DRV pfet L=0.55U W=10U AS=2.1P AD=2.1P PS=10.42U
+ PD=10.42U
* device instance $865 r0 *1 89.935,440.17 pfet
M$865 OUT x2_n5 VDD_DRV VDD_DRV pfet L=0.55U W=10U AS=2.1P AD=2.1P PS=10.42U
+ PD=10.42U
* device instance $866 r0 *1 90.905,440.17 pfet
M$866 VDD_DRV x2_n5 OUT VDD_DRV pfet L=0.55U W=10U AS=2.1P AD=2.1P PS=10.42U
+ PD=10.42U
* device instance $867 r0 *1 91.875,440.17 pfet
M$867 OUT x2_n5 VDD_DRV VDD_DRV pfet L=0.55U W=10U AS=2.1P AD=2.1P PS=10.42U
+ PD=10.42U
* device instance $868 r0 *1 92.845,440.17 pfet
M$868 VDD_DRV x2_n5 OUT VDD_DRV pfet L=0.55U W=10U AS=2.1P AD=2.1P PS=10.42U
+ PD=10.42U
* device instance $869 r0 *1 93.815,440.17 pfet
M$869 OUT x2_n5 VDD_DRV VDD_DRV pfet L=0.55U W=10U AS=2.1P AD=2.1P PS=10.42U
+ PD=10.42U
* device instance $870 r0 *1 94.785,440.17 pfet
M$870 VDD_DRV x2_n5 OUT VDD_DRV pfet L=0.55U W=10U AS=2.1P AD=2.1P PS=10.42U
+ PD=10.42U
* device instance $871 r0 *1 95.755,440.17 pfet
M$871 OUT x2_n5 VDD_DRV VDD_DRV pfet L=0.55U W=10U AS=2.1P AD=2.1P PS=10.42U
+ PD=10.42U
* device instance $872 r0 *1 96.725,440.17 pfet
M$872 VDD_DRV x2_n5 OUT VDD_DRV pfet L=0.55U W=10U AS=2.1P AD=2.1P PS=10.42U
+ PD=10.42U
* device instance $873 r0 *1 97.695,440.17 pfet
M$873 OUT x2_n5 VDD_DRV VDD_DRV pfet L=0.55U W=10U AS=2.1P AD=2.1P PS=10.42U
+ PD=10.42U
* device instance $874 r0 *1 98.665,440.17 pfet
M$874 VDD_DRV x2_n5 OUT VDD_DRV pfet L=0.55U W=10U AS=2.1P AD=2.1P PS=10.42U
+ PD=10.42U
* device instance $875 r0 *1 99.635,440.17 pfet
M$875 OUT x2_n5 VDD_DRV VDD_DRV pfet L=0.55U W=10U AS=2.1P AD=2.1P PS=10.42U
+ PD=10.42U
* device instance $876 r0 *1 100.605,440.17 pfet
M$876 VDD_DRV x2_n5 OUT VDD_DRV pfet L=0.55U W=10U AS=2.1P AD=2.1P PS=10.42U
+ PD=10.42U
* device instance $877 r0 *1 101.575,440.17 pfet
M$877 OUT x2_n5 VDD_DRV VDD_DRV pfet L=0.55U W=10U AS=2.1P AD=2.1P PS=10.42U
+ PD=10.42U
* device instance $878 r0 *1 102.545,440.17 pfet
M$878 VDD_DRV x2_n5 OUT VDD_DRV pfet L=0.55U W=10U AS=2.1P AD=2.1P PS=10.42U
+ PD=10.42U
* device instance $879 r0 *1 103.515,440.17 pfet
M$879 OUT x2_n5 VDD_DRV VDD_DRV pfet L=0.55U W=10U AS=2.1P AD=2.1P PS=10.42U
+ PD=10.42U
* device instance $880 r0 *1 104.485,440.17 pfet
M$880 VDD_DRV x2_n5 OUT VDD_DRV pfet L=0.55U W=10U AS=2.1P AD=2.1P PS=10.42U
+ PD=10.42U
* device instance $881 r0 *1 105.455,440.17 pfet
M$881 OUT x2_n5 VDD_DRV VDD_DRV pfet L=0.55U W=10U AS=2.1P AD=2.1P PS=10.42U
+ PD=10.42U
* device instance $882 r0 *1 106.425,440.17 pfet
M$882 VDD_DRV x2_n5 OUT VDD_DRV pfet L=0.55U W=10U AS=2.1P AD=2.1P PS=10.42U
+ PD=10.42U
* device instance $883 r0 *1 107.395,440.17 pfet
M$883 OUT x2_n5 VDD_DRV VDD_DRV pfet L=0.55U W=10U AS=2.1P AD=2.1P PS=10.42U
+ PD=10.42U
* device instance $884 r0 *1 108.365,440.17 pfet
M$884 VDD_DRV x2_n5 OUT VDD_DRV pfet L=0.55U W=10U AS=2.1P AD=2.1P PS=10.42U
+ PD=10.42U
* device instance $885 r0 *1 109.335,440.17 pfet
M$885 OUT x2_n5 VDD_DRV VDD_DRV pfet L=0.55U W=10U AS=2.1P AD=2.1P PS=10.42U
+ PD=10.42U
* device instance $886 r0 *1 110.305,440.17 pfet
M$886 VDD_DRV x2_n5 OUT VDD_DRV pfet L=0.55U W=10U AS=2.1P AD=2.1P PS=10.42U
+ PD=10.42U
* device instance $887 r0 *1 111.275,440.17 pfet
M$887 OUT x2_n5 VDD_DRV VDD_DRV pfet L=0.55U W=10U AS=2.1P AD=2.1P PS=10.42U
+ PD=10.42U
* device instance $888 r0 *1 112.245,440.17 pfet
M$888 VDD_DRV x2_n5 OUT VDD_DRV pfet L=0.55U W=10U AS=2.1P AD=2.1P PS=10.42U
+ PD=10.42U
* device instance $889 r0 *1 113.215,440.17 pfet
M$889 OUT x2_n5 VDD_DRV VDD_DRV pfet L=0.55U W=10U AS=2.1P AD=2.1P PS=10.42U
+ PD=10.42U
* device instance $890 r0 *1 114.185,440.17 pfet
M$890 VDD_DRV x2_n5 OUT VDD_DRV pfet L=0.55U W=10U AS=2.1P AD=2.1P PS=10.42U
+ PD=10.42U
* device instance $891 r0 *1 115.155,440.17 pfet
M$891 OUT x2_n5 VDD_DRV VDD_DRV pfet L=0.55U W=10U AS=2.1P AD=2.1P PS=10.42U
+ PD=10.42U
* device instance $892 r0 *1 116.125,440.17 pfet
M$892 VDD_DRV x2_n5 OUT VDD_DRV pfet L=0.55U W=10U AS=2.1P AD=2.1P PS=10.42U
+ PD=10.42U
* device instance $893 r0 *1 117.095,440.17 pfet
M$893 OUT x2_n5 VDD_DRV VDD_DRV pfet L=0.55U W=10U AS=2.1P AD=2.1P PS=10.42U
+ PD=10.42U
* device instance $894 r0 *1 118.065,440.17 pfet
M$894 VDD_DRV x2_n5 OUT VDD_DRV pfet L=0.55U W=10U AS=2.1P AD=2.1P PS=10.42U
+ PD=10.42U
* device instance $895 r0 *1 119.035,440.17 pfet
M$895 OUT x2_n5 VDD_DRV VDD_DRV pfet L=0.55U W=10U AS=2.1P AD=2.1P PS=10.42U
+ PD=10.42U
* device instance $896 r0 *1 120.005,440.17 pfet
M$896 VDD_DRV x2_n5 OUT VDD_DRV pfet L=0.55U W=10U AS=2.1P AD=2.1P PS=10.42U
+ PD=10.42U
* device instance $897 r0 *1 120.975,440.17 pfet
M$897 OUT x2_n5 VDD_DRV VDD_DRV pfet L=0.55U W=10U AS=2.1P AD=2.1P PS=10.42U
+ PD=10.42U
* device instance $898 r0 *1 1.665,440.17 pfet
M$898 VDD_DRV x2_n5 OUT VDD_DRV pfet L=0.55U W=10U AS=2.1P AD=2.1P PS=10.42U
+ PD=10.42U
* device instance $899 r0 *1 2.635,440.17 pfet
M$899 OUT x2_n5 VDD_DRV VDD_DRV pfet L=0.55U W=10U AS=2.1P AD=2.1P PS=10.42U
+ PD=10.42U
* device instance $900 r0 *1 3.605,440.17 pfet
M$900 VDD_DRV x2_n5 OUT VDD_DRV pfet L=0.55U W=10U AS=2.1P AD=2.1P PS=10.42U
+ PD=10.42U
* device instance $901 r0 *1 4.575,440.17 pfet
M$901 OUT x2_n5 VDD_DRV VDD_DRV pfet L=0.55U W=10U AS=2.1P AD=2.1P PS=10.42U
+ PD=10.42U
* device instance $902 r0 *1 5.545,440.17 pfet
M$902 VDD_DRV x2_n5 OUT VDD_DRV pfet L=0.55U W=10U AS=2.1P AD=2.1P PS=10.42U
+ PD=10.42U
* device instance $903 r0 *1 6.515,440.17 pfet
M$903 OUT x2_n5 VDD_DRV VDD_DRV pfet L=0.55U W=10U AS=2.1P AD=2.1P PS=10.42U
+ PD=10.42U
* device instance $904 r0 *1 7.485,440.17 pfet
M$904 VDD_DRV x2_n5 OUT VDD_DRV pfet L=0.55U W=10U AS=2.1P AD=2.1P PS=10.42U
+ PD=10.42U
* device instance $905 r0 *1 8.455,440.17 pfet
M$905 OUT x2_n5 VDD_DRV VDD_DRV pfet L=0.55U W=10U AS=2.1P AD=2.1P PS=10.42U
+ PD=10.42U
* device instance $906 r0 *1 9.425,440.17 pfet
M$906 VDD_DRV x2_n5 OUT VDD_DRV pfet L=0.55U W=10U AS=2.1P AD=2.1P PS=10.42U
+ PD=10.42U
* device instance $907 r0 *1 10.395,440.17 pfet
M$907 OUT x2_n5 VDD_DRV VDD_DRV pfet L=0.55U W=10U AS=2.1P AD=2.1P PS=10.42U
+ PD=10.42U
* device instance $908 r0 *1 11.365,440.17 pfet
M$908 VDD_DRV x2_n5 OUT VDD_DRV pfet L=0.55U W=10U AS=2.1P AD=2.1P PS=10.42U
+ PD=10.42U
* device instance $909 r0 *1 12.335,440.17 pfet
M$909 OUT x2_n5 VDD_DRV VDD_DRV pfet L=0.55U W=10U AS=2.1P AD=2.1P PS=10.42U
+ PD=10.42U
* device instance $910 r0 *1 13.305,440.17 pfet
M$910 VDD_DRV x2_n5 OUT VDD_DRV pfet L=0.55U W=10U AS=2.1P AD=2.1P PS=10.42U
+ PD=10.42U
* device instance $911 r0 *1 14.275,440.17 pfet
M$911 OUT x2_n5 VDD_DRV VDD_DRV pfet L=0.55U W=10U AS=2.1P AD=2.1P PS=10.42U
+ PD=10.42U
* device instance $912 r0 *1 15.245,440.17 pfet
M$912 VDD_DRV x2_n5 OUT VDD_DRV pfet L=0.55U W=10U AS=2.1P AD=2.1P PS=10.42U
+ PD=10.42U
* device instance $913 r0 *1 16.215,440.17 pfet
M$913 OUT x2_n5 VDD_DRV VDD_DRV pfet L=0.55U W=10U AS=2.1P AD=2.1P PS=10.42U
+ PD=10.42U
* device instance $914 r0 *1 17.185,440.17 pfet
M$914 VDD_DRV x2_n5 OUT VDD_DRV pfet L=0.55U W=10U AS=2.1P AD=2.1P PS=10.42U
+ PD=10.42U
* device instance $915 r0 *1 18.155,440.17 pfet
M$915 OUT x2_n5 VDD_DRV VDD_DRV pfet L=0.55U W=10U AS=2.1P AD=2.1P PS=10.42U
+ PD=10.42U
* device instance $916 r0 *1 19.125,440.17 pfet
M$916 VDD_DRV x2_n5 OUT VDD_DRV pfet L=0.55U W=10U AS=2.1P AD=2.1P PS=10.42U
+ PD=10.42U
* device instance $917 r0 *1 20.095,440.17 pfet
M$917 OUT x2_n5 VDD_DRV VDD_DRV pfet L=0.55U W=10U AS=2.1P AD=2.1P PS=10.42U
+ PD=10.42U
* device instance $918 r0 *1 21.065,440.17 pfet
M$918 VDD_DRV x2_n5 OUT VDD_DRV pfet L=0.55U W=10U AS=2.1P AD=2.1P PS=10.42U
+ PD=10.42U
* device instance $919 r0 *1 22.035,440.17 pfet
M$919 OUT x2_n5 VDD_DRV VDD_DRV pfet L=0.55U W=10U AS=2.1P AD=2.1P PS=10.42U
+ PD=10.42U
* device instance $920 r0 *1 23.005,440.17 pfet
M$920 VDD_DRV x2_n5 OUT VDD_DRV pfet L=0.55U W=10U AS=2.1P AD=2.1P PS=10.42U
+ PD=10.42U
* device instance $921 r0 *1 23.975,440.17 pfet
M$921 OUT x2_n5 VDD_DRV VDD_DRV pfet L=0.55U W=10U AS=2.1P AD=2.1P PS=10.42U
+ PD=10.42U
* device instance $922 r0 *1 24.945,440.17 pfet
M$922 VDD_DRV x2_n5 OUT VDD_DRV pfet L=0.55U W=10U AS=2.1P AD=2.1P PS=10.42U
+ PD=10.42U
* device instance $923 r0 *1 25.915,440.17 pfet
M$923 OUT x2_n5 VDD_DRV VDD_DRV pfet L=0.55U W=10U AS=2.1P AD=2.1P PS=10.42U
+ PD=10.42U
* device instance $924 r0 *1 26.885,440.17 pfet
M$924 VDD_DRV x2_n5 OUT VDD_DRV pfet L=0.55U W=10U AS=2.1P AD=2.1P PS=10.42U
+ PD=10.42U
* device instance $925 r0 *1 27.855,440.17 pfet
M$925 OUT x2_n5 VDD_DRV VDD_DRV pfet L=0.55U W=10U AS=2.1P AD=2.1P PS=10.42U
+ PD=10.42U
* device instance $926 r0 *1 28.825,440.17 pfet
M$926 VDD_DRV x2_n5 OUT VDD_DRV pfet L=0.55U W=10U AS=2.1P AD=2.1P PS=10.42U
+ PD=10.42U
* device instance $927 r0 *1 29.795,440.17 pfet
M$927 OUT x2_n5 VDD_DRV VDD_DRV pfet L=0.55U W=10U AS=2.1P AD=2.1P PS=10.42U
+ PD=10.42U
* device instance $928 r0 *1 30.765,440.17 pfet
M$928 VDD_DRV x2_n5 OUT VDD_DRV pfet L=0.55U W=10U AS=2.1P AD=2.1P PS=10.42U
+ PD=10.42U
* device instance $929 r0 *1 31.735,440.17 pfet
M$929 OUT x2_n5 VDD_DRV VDD_DRV pfet L=0.55U W=10U AS=2.1P AD=2.1P PS=10.42U
+ PD=10.42U
* device instance $930 r0 *1 32.705,440.17 pfet
M$930 VDD_DRV x2_n5 OUT VDD_DRV pfet L=0.55U W=10U AS=2.1P AD=2.1P PS=10.42U
+ PD=10.42U
* device instance $931 r0 *1 33.675,440.17 pfet
M$931 OUT x2_n5 VDD_DRV VDD_DRV pfet L=0.55U W=10U AS=2.1P AD=2.1P PS=10.42U
+ PD=10.42U
* device instance $932 r0 *1 34.645,440.17 pfet
M$932 VDD_DRV x2_n5 OUT VDD_DRV pfet L=0.55U W=10U AS=2.1P AD=2.1P PS=10.42U
+ PD=10.42U
* device instance $933 r0 *1 35.615,440.17 pfet
M$933 OUT x2_n5 VDD_DRV VDD_DRV pfet L=0.55U W=10U AS=2.1P AD=2.1P PS=10.42U
+ PD=10.42U
* device instance $934 r0 *1 36.585,440.17 pfet
M$934 VDD_DRV x2_n5 OUT VDD_DRV pfet L=0.55U W=10U AS=2.1P AD=2.1P PS=10.42U
+ PD=10.42U
* device instance $935 r0 *1 37.555,440.17 pfet
M$935 OUT x2_n5 VDD_DRV VDD_DRV pfet L=0.55U W=10U AS=2.1P AD=2.1P PS=10.42U
+ PD=10.42U
* device instance $936 r0 *1 38.525,440.17 pfet
M$936 VDD_DRV x2_n5 OUT VDD_DRV pfet L=0.55U W=10U AS=2.1P AD=2.1P PS=10.42U
+ PD=10.42U
* device instance $937 r0 *1 39.495,440.17 pfet
M$937 OUT x2_n5 VDD_DRV VDD_DRV pfet L=0.55U W=10U AS=2.1P AD=2.1P PS=10.42U
+ PD=10.42U
* device instance $938 r0 *1 40.465,440.17 pfet
M$938 VDD_DRV x2_n5 OUT VDD_DRV pfet L=0.55U W=10U AS=2.1P AD=2.1P PS=10.42U
+ PD=10.42U
* device instance $939 r0 *1 41.435,440.17 pfet
M$939 OUT x2_n5 VDD_DRV VDD_DRV pfet L=0.55U W=10U AS=2.1P AD=2.1P PS=10.42U
+ PD=10.42U
* device instance $940 r0 *1 42.405,440.17 pfet
M$940 VDD_DRV x2_n5 OUT VDD_DRV pfet L=0.55U W=10U AS=2.1P AD=2.1P PS=10.42U
+ PD=10.42U
* device instance $941 r0 *1 43.375,440.17 pfet
M$941 OUT x2_n5 VDD_DRV VDD_DRV pfet L=0.55U W=10U AS=2.1P AD=2.1P PS=10.42U
+ PD=10.42U
* device instance $942 r0 *1 44.345,440.17 pfet
M$942 VDD_DRV x2_n5 OUT VDD_DRV pfet L=0.55U W=10U AS=2.1P AD=2.1P PS=10.42U
+ PD=10.42U
* device instance $943 r0 *1 45.315,440.17 pfet
M$943 OUT x2_n5 VDD_DRV VDD_DRV pfet L=0.55U W=10U AS=2.1P AD=2.1P PS=10.42U
+ PD=10.42U
* device instance $944 r0 *1 46.285,440.17 pfet
M$944 VDD_DRV x2_n5 OUT VDD_DRV pfet L=0.55U W=10U AS=2.1P AD=2.1P PS=10.42U
+ PD=10.42U
* device instance $945 r0 *1 47.255,440.17 pfet
M$945 OUT x2_n5 VDD_DRV VDD_DRV pfet L=0.55U W=10U AS=2.1P AD=2.1P PS=10.42U
+ PD=10.42U
* device instance $946 r0 *1 48.225,440.17 pfet
M$946 VDD_DRV x2_n5 OUT VDD_DRV pfet L=0.55U W=10U AS=2.1P AD=2.1P PS=10.42U
+ PD=10.42U
* device instance $947 r0 *1 49.195,440.17 pfet
M$947 OUT x2_n5 VDD_DRV VDD_DRV pfet L=0.55U W=10U AS=2.1P AD=2.1P PS=10.42U
+ PD=10.42U
* device instance $948 r0 *1 50.165,440.17 pfet
M$948 VDD_DRV x2_n5 OUT VDD_DRV pfet L=0.55U W=10U AS=2.1P AD=2.1P PS=10.42U
+ PD=10.42U
* device instance $949 r0 *1 51.135,440.17 pfet
M$949 OUT x2_n5 VDD_DRV VDD_DRV pfet L=0.55U W=10U AS=2.1P AD=2.1P PS=10.42U
+ PD=10.42U
* device instance $950 r0 *1 52.105,440.17 pfet
M$950 VDD_DRV x2_n5 OUT VDD_DRV pfet L=0.55U W=10U AS=2.1P AD=2.1P PS=10.42U
+ PD=10.42U
* device instance $951 r0 *1 53.075,440.17 pfet
M$951 OUT x2_n5 VDD_DRV VDD_DRV pfet L=0.55U W=10U AS=2.1P AD=2.1P PS=10.42U
+ PD=10.42U
* device instance $952 r0 *1 54.045,440.17 pfet
M$952 VDD_DRV x2_n5 OUT VDD_DRV pfet L=0.55U W=10U AS=2.1P AD=2.1P PS=10.42U
+ PD=10.42U
* device instance $953 r0 *1 55.015,440.17 pfet
M$953 OUT x2_n5 VDD_DRV VDD_DRV pfet L=0.55U W=10U AS=2.1P AD=2.1P PS=10.42U
+ PD=10.42U
* device instance $954 r0 *1 55.985,440.17 pfet
M$954 VDD_DRV x2_n5 OUT VDD_DRV pfet L=0.55U W=10U AS=2.1P AD=2.1P PS=10.42U
+ PD=10.42U
* device instance $955 r0 *1 56.955,440.17 pfet
M$955 OUT x2_n5 VDD_DRV VDD_DRV pfet L=0.55U W=10U AS=2.1P AD=2.1P PS=10.42U
+ PD=10.42U
* device instance $956 r0 *1 57.925,440.17 pfet
M$956 VDD_DRV x2_n5 OUT VDD_DRV pfet L=0.55U W=10U AS=2.1P AD=2.1P PS=10.42U
+ PD=10.42U
* device instance $957 r0 *1 58.895,440.17 pfet
M$957 OUT x2_n5 VDD_DRV VDD_DRV pfet L=0.55U W=10U AS=2.1P AD=2.1P PS=10.42U
+ PD=10.42U
* device instance $958 r0 *1 59.865,440.17 pfet
M$958 VDD_DRV x2_n5 OUT VDD_DRV pfet L=0.55U W=10U AS=2.1P AD=2.1P PS=10.42U
+ PD=10.42U
* device instance $959 r0 *1 0.695,440.17 pfet
M$959 OUT x2_n5 VDD_DRV VDD_DRV pfet L=0.55U W=10U AS=4.2P AD=2.1P PS=20.84U
+ PD=10.42U
* device instance $960 r0 *1 3.1,507.82 cap_mim_2f0_m4m5_noshield
C$960 x1_ncb \$18 5.4516e-14 cap_mim_2f0_m4m5_noshield
* device instance $961 r0 *1 10.5,507.82 cap_mim_2f0_m4m5_noshield
C$961 \$19 \$18 5.4516e-14 cap_mim_2f0_m4m5_noshield
* device instance $962 r0 *1 17.9,507.82 cap_mim_2f0_m4m5_noshield
C$962 \$19 \$20 5.4516e-14 cap_mim_2f0_m4m5_noshield
* device instance $963 r0 *1 25.3,507.82 cap_mim_2f0_m4m5_noshield
C$963 IN_DRV \$20 5.4516e-14 cap_mim_2f0_m4m5_noshield
.ENDS gate_driver_core
