* extracted by klt extract --deck gf180mcu

* cell gate_driver_core
* pin GND_DRV
* pin GND_LOGIC
* pin IN
* pin IN_DRV
* pin OUT
* pin VDD_DRV
* pin VDD_LOGIC
* pin x1_inb
* pin x1_na
* pin x1_nb
* pin x1_nbuf1
* pin x1_nca
* pin x1_ncb
* pin x2_n1
* pin x2_n2
* pin x2_n3
* pin x2_n4
* pin x2_n5
* pin x3_lockout
* pin x3_ncompn
* pin x3_ncompp
* pin x3_ndiv
* pin x3_nref
* pin x3_ntail
* pin x3_uvlo_ok
.SUBCKT gate_driver_core GND_DRV GND_LOGIC IN IN_DRV OUT VDD_DRV VDD_LOGIC
+ x1_inb x1_na x1_nb x1_nbuf1 x1_nca x1_ncb x2_n1 x2_n2 x2_n3 x2_n4 x2_n5
+ x3_lockout x3_ncompn x3_ncompp x3_ndiv x3_nref x3_ntail x3_uvlo_ok
* device instance $1 r0 *1 0.56,2.5 nfet
M$1 x1_inb IN GND_LOGIC GND_LOGIC nfet L=0.28U W=5U AS=2.1P AD=2.1P PS=10.84U
+ PD=10.84U
* device instance $2 r0 *1 0.56,33.34 nfet
M$2 x1_na IN GND_LOGIC GND_LOGIC nfet L=0.28U W=20U AS=8.4P AD=8.4P PS=40.84U
+ PD=40.84U
* device instance $3 r0 *1 0.56,57.36 nfet
M$3 x1_nb x1_inb GND_LOGIC GND_LOGIC nfet L=0.28U W=20U AS=8.4P AD=8.4P
+ PS=40.84U PD=40.84U
* device instance $4 r0 *1 0.56,14.17 pfet
M$4 x1_inb IN VDD_LOGIC VDD_LOGIC pfet L=0.28U W=10U AS=4.2P AD=4.2P PS=20.84U
+ PD=20.84U
* device instance $5 r0 *1 0.77,98.18 nfet
M$5 x1_nca VDD_LOGIC x1_na GND_LOGIC nfet L=0.7U W=20U AS=8.4P AD=8.4P
+ PS=40.84U PD=40.84U
* device instance $6 r0 *1 0.77,122.2 nfet
M$6 x1_ncb VDD_LOGIC x1_nb GND_LOGIC nfet L=0.7U W=20U AS=8.4P AD=8.4P
+ PS=40.84U PD=40.84U
* device instance $7 r0 *1 0.77,162.68 nfet
M$7 x1_nbuf1 x1_ncb GND_DRV GND_LOGIC nfet L=0.7U W=5U AS=2.1P AD=2.1P
+ PS=10.84U PD=10.84U
* device instance $8 r0 *1 0.77,196.02 nfet
M$8 IN_DRV x1_nbuf1 GND_DRV GND_LOGIC nfet L=0.7U W=15U AS=6.3P AD=6.3P
+ PS=30.84U PD=30.84U
* device instance $9 r0 *1 0.77,217.26 nfet
M$9 x2_n1 IN_DRV GND_DRV GND_LOGIC nfet L=0.7U W=2U AS=0.84P AD=0.84P PS=4.84U
+ PD=4.84U
* device instance $10 r0 *1 0.77,248.6 nfet
M$10 x2_n2 x2_n1 GND_DRV GND_LOGIC nfet L=0.7U W=8U AS=3.36P AD=3.36P PS=16.84U
+ PD=16.84U
* device instance $11 r0 *1 0.77,350.44 nfet
M$11 x2_n3 x2_n2 GND_DRV GND_LOGIC nfet L=0.7U W=33U AS=13.86P AD=13.86P
+ PS=66.84U PD=66.84U
* device instance $12 r0 *1 0.77,392.74 nfet
M$12 x2_n4 x2_n3 GND_DRV GND_LOGIC nfet L=0.7U W=10U AS=4.2P AD=2.1P PS=20.84U
+ PD=10.42U
* device instance $13 r0 *1 1.89,392.74 nfet
M$13 GND_DRV x2_n3 x2_n4 GND_LOGIC nfet L=0.7U W=10U AS=2.1P AD=2.1P PS=10.42U
+ PD=10.42U
* device instance $14 r0 *1 3.01,392.74 nfet
M$14 x2_n4 x2_n3 GND_DRV GND_LOGIC nfet L=0.7U W=10U AS=2.1P AD=2.1P PS=10.42U
+ PD=10.42U
* device instance $15 r0 *1 4.13,392.74 nfet
M$15 GND_DRV x2_n3 x2_n4 GND_LOGIC nfet L=0.7U W=10U AS=2.1P AD=2.1P PS=10.42U
+ PD=10.42U
* device instance $16 r0 *1 5.25,392.74 nfet
M$16 x2_n4 x2_n3 GND_DRV GND_LOGIC nfet L=0.7U W=10U AS=2.1P AD=2.1P PS=10.42U
+ PD=10.42U
* device instance $17 r0 *1 6.37,392.74 nfet
M$17 GND_DRV x2_n3 x2_n4 GND_LOGIC nfet L=0.7U W=10U AS=2.1P AD=2.1P PS=10.42U
+ PD=10.42U
* device instance $18 r0 *1 7.49,392.74 nfet
M$18 x2_n4 x2_n3 GND_DRV GND_LOGIC nfet L=0.7U W=10U AS=2.1P AD=2.1P PS=10.42U
+ PD=10.42U
* device instance $19 r0 *1 8.61,392.74 nfet
M$19 GND_DRV x2_n3 x2_n4 GND_LOGIC nfet L=0.7U W=10U AS=2.1P AD=2.1P PS=10.42U
+ PD=10.42U
* device instance $20 r0 *1 9.73,392.74 nfet
M$20 x2_n4 x2_n3 GND_DRV GND_LOGIC nfet L=0.7U W=10U AS=2.1P AD=2.1P PS=10.42U
+ PD=10.42U
* device instance $21 r0 *1 10.85,392.74 nfet
M$21 GND_DRV x2_n3 x2_n4 GND_LOGIC nfet L=0.7U W=10U AS=2.1P AD=2.1P PS=10.42U
+ PD=10.42U
* device instance $22 r0 *1 11.97,392.74 nfet
M$22 x2_n4 x2_n3 GND_DRV GND_LOGIC nfet L=0.7U W=10U AS=2.1P AD=2.1P PS=10.42U
+ PD=10.42U
* device instance $23 r0 *1 13.09,392.74 nfet
M$23 GND_DRV x2_n3 x2_n4 GND_LOGIC nfet L=0.7U W=10U AS=2.1P AD=2.1P PS=10.42U
+ PD=10.42U
* device instance $24 r0 *1 14.21,392.74 nfet
M$24 x2_n4 x2_n3 GND_DRV GND_LOGIC nfet L=0.7U W=10U AS=2.1P AD=2.1P PS=10.42U
+ PD=10.42U
* device instance $25 r0 *1 15.33,392.74 nfet
M$25 GND_DRV x2_n3 x2_n4 GND_LOGIC nfet L=0.7U W=10U AS=2.1P AD=4.2P PS=10.42U
+ PD=20.84U
* device instance $26 r0 *1 0.77,424.36 nfet
M$26 x2_n5 x2_n4 GND_DRV GND_LOGIC nfet L=0.7U W=10U AS=4.2P AD=2.1P PS=20.84U
+ PD=10.42U
* device instance $27 r0 *1 1.89,424.36 nfet
M$27 GND_DRV x2_n4 x2_n5 GND_LOGIC nfet L=0.7U W=10U AS=2.1P AD=2.1P PS=10.42U
+ PD=10.42U
* device instance $28 r0 *1 3.01,424.36 nfet
M$28 x2_n5 x2_n4 GND_DRV GND_LOGIC nfet L=0.7U W=10U AS=2.1P AD=2.1P PS=10.42U
+ PD=10.42U
* device instance $29 r0 *1 4.13,424.36 nfet
M$29 GND_DRV x2_n4 x2_n5 GND_LOGIC nfet L=0.7U W=10U AS=2.1P AD=2.1P PS=10.42U
+ PD=10.42U
* device instance $30 r0 *1 5.25,424.36 nfet
M$30 x2_n5 x2_n4 GND_DRV GND_LOGIC nfet L=0.7U W=10U AS=2.1P AD=2.1P PS=10.42U
+ PD=10.42U
* device instance $31 r0 *1 6.37,424.36 nfet
M$31 GND_DRV x2_n4 x2_n5 GND_LOGIC nfet L=0.7U W=10U AS=2.1P AD=2.1P PS=10.42U
+ PD=10.42U
* device instance $32 r0 *1 7.49,424.36 nfet
M$32 x2_n5 x2_n4 GND_DRV GND_LOGIC nfet L=0.7U W=10U AS=2.1P AD=2.1P PS=10.42U
+ PD=10.42U
* device instance $33 r0 *1 8.61,424.36 nfet
M$33 GND_DRV x2_n4 x2_n5 GND_LOGIC nfet L=0.7U W=10U AS=2.1P AD=2.1P PS=10.42U
+ PD=10.42U
* device instance $34 r0 *1 9.73,424.36 nfet
M$34 x2_n5 x2_n4 GND_DRV GND_LOGIC nfet L=0.7U W=10U AS=2.1P AD=2.1P PS=10.42U
+ PD=10.42U
* device instance $35 r0 *1 10.85,424.36 nfet
M$35 GND_DRV x2_n4 x2_n5 GND_LOGIC nfet L=0.7U W=10U AS=2.1P AD=2.1P PS=10.42U
+ PD=10.42U
* device instance $36 r0 *1 11.97,424.36 nfet
M$36 x2_n5 x2_n4 GND_DRV GND_LOGIC nfet L=0.7U W=10U AS=2.1P AD=2.1P PS=10.42U
+ PD=10.42U
* device instance $37 r0 *1 13.09,424.36 nfet
M$37 GND_DRV x2_n4 x2_n5 GND_LOGIC nfet L=0.7U W=10U AS=2.1P AD=2.1P PS=10.42U
+ PD=10.42U
* device instance $38 r0 *1 14.21,424.36 nfet
M$38 x2_n5 x2_n4 GND_DRV GND_LOGIC nfet L=0.7U W=10U AS=2.1P AD=2.1P PS=10.42U
+ PD=10.42U
* device instance $39 r0 *1 15.33,424.36 nfet
M$39 GND_DRV x2_n4 x2_n5 GND_LOGIC nfet L=0.7U W=10U AS=2.1P AD=2.1P PS=10.42U
+ PD=10.42U
* device instance $40 r0 *1 16.45,424.36 nfet
M$40 x2_n5 x2_n4 GND_DRV GND_LOGIC nfet L=0.7U W=10U AS=2.1P AD=2.1P PS=10.42U
+ PD=10.42U
* device instance $41 r0 *1 17.57,424.36 nfet
M$41 GND_DRV x2_n4 x2_n5 GND_LOGIC nfet L=0.7U W=10U AS=2.1P AD=2.1P PS=10.42U
+ PD=10.42U
* device instance $42 r0 *1 18.69,424.36 nfet
M$42 x2_n5 x2_n4 GND_DRV GND_LOGIC nfet L=0.7U W=10U AS=2.1P AD=2.1P PS=10.42U
+ PD=10.42U
* device instance $43 r0 *1 19.81,424.36 nfet
M$43 GND_DRV x2_n4 x2_n5 GND_LOGIC nfet L=0.7U W=10U AS=2.1P AD=2.1P PS=10.42U
+ PD=10.42U
* device instance $44 r0 *1 20.93,424.36 nfet
M$44 x2_n5 x2_n4 GND_DRV GND_LOGIC nfet L=0.7U W=10U AS=2.1P AD=2.1P PS=10.42U
+ PD=10.42U
* device instance $45 r0 *1 22.05,424.36 nfet
M$45 GND_DRV x2_n4 x2_n5 GND_LOGIC nfet L=0.7U W=10U AS=2.1P AD=2.1P PS=10.42U
+ PD=10.42U
* device instance $46 r0 *1 23.17,424.36 nfet
M$46 x2_n5 x2_n4 GND_DRV GND_LOGIC nfet L=0.7U W=10U AS=2.1P AD=2.1P PS=10.42U
+ PD=10.42U
* device instance $47 r0 *1 24.29,424.36 nfet
M$47 GND_DRV x2_n4 x2_n5 GND_LOGIC nfet L=0.7U W=10U AS=2.1P AD=2.1P PS=10.42U
+ PD=10.42U
* device instance $48 r0 *1 25.41,424.36 nfet
M$48 x2_n5 x2_n4 GND_DRV GND_LOGIC nfet L=0.7U W=10U AS=2.1P AD=2.1P PS=10.42U
+ PD=10.42U
* device instance $49 r0 *1 26.53,424.36 nfet
M$49 GND_DRV x2_n4 x2_n5 GND_LOGIC nfet L=0.7U W=10U AS=2.1P AD=2.1P PS=10.42U
+ PD=10.42U
* device instance $50 r0 *1 27.65,424.36 nfet
M$50 x2_n5 x2_n4 GND_DRV GND_LOGIC nfet L=0.7U W=10U AS=2.1P AD=2.1P PS=10.42U
+ PD=10.42U
* device instance $51 r0 *1 28.77,424.36 nfet
M$51 GND_DRV x2_n4 x2_n5 GND_LOGIC nfet L=0.7U W=10U AS=2.1P AD=2.1P PS=10.42U
+ PD=10.42U
* device instance $52 r0 *1 29.89,424.36 nfet
M$52 x2_n5 x2_n4 GND_DRV GND_LOGIC nfet L=0.7U W=10U AS=2.1P AD=2.1P PS=10.42U
+ PD=10.42U
* device instance $53 r0 *1 31.01,424.36 nfet
M$53 GND_DRV x2_n4 x2_n5 GND_LOGIC nfet L=0.7U W=10U AS=2.1P AD=2.1P PS=10.42U
+ PD=10.42U
* device instance $54 r0 *1 32.13,424.36 nfet
M$54 x2_n5 x2_n4 GND_DRV GND_LOGIC nfet L=0.7U W=10U AS=2.1P AD=2.1P PS=10.42U
+ PD=10.42U
* device instance $55 r0 *1 33.25,424.36 nfet
M$55 GND_DRV x2_n4 x2_n5 GND_LOGIC nfet L=0.7U W=10U AS=2.1P AD=2.1P PS=10.42U
+ PD=10.42U
* device instance $56 r0 *1 34.37,424.36 nfet
M$56 x2_n5 x2_n4 GND_DRV GND_LOGIC nfet L=0.7U W=10U AS=2.1P AD=2.1P PS=10.42U
+ PD=10.42U
* device instance $57 r0 *1 35.49,424.36 nfet
M$57 GND_DRV x2_n4 x2_n5 GND_LOGIC nfet L=0.7U W=10U AS=2.1P AD=2.1P PS=10.42U
+ PD=10.42U
* device instance $58 r0 *1 36.61,424.36 nfet
M$58 x2_n5 x2_n4 GND_DRV GND_LOGIC nfet L=0.7U W=10U AS=2.1P AD=2.1P PS=10.42U
+ PD=10.42U
* device instance $59 r0 *1 37.73,424.36 nfet
M$59 GND_DRV x2_n4 x2_n5 GND_LOGIC nfet L=0.7U W=10U AS=2.1P AD=2.1P PS=10.42U
+ PD=10.42U
* device instance $60 r0 *1 38.85,424.36 nfet
M$60 x2_n5 x2_n4 GND_DRV GND_LOGIC nfet L=0.7U W=10U AS=2.1P AD=2.1P PS=10.42U
+ PD=10.42U
* device instance $61 r0 *1 39.97,424.36 nfet
M$61 GND_DRV x2_n4 x2_n5 GND_LOGIC nfet L=0.7U W=10U AS=2.1P AD=2.1P PS=10.42U
+ PD=10.42U
* device instance $62 r0 *1 41.09,424.36 nfet
M$62 x2_n5 x2_n4 GND_DRV GND_LOGIC nfet L=0.7U W=10U AS=2.1P AD=2.1P PS=10.42U
+ PD=10.42U
* device instance $63 r0 *1 42.21,424.36 nfet
M$63 GND_DRV x2_n4 x2_n5 GND_LOGIC nfet L=0.7U W=10U AS=2.1P AD=2.1P PS=10.42U
+ PD=10.42U
* device instance $64 r0 *1 43.33,424.36 nfet
M$64 x2_n5 x2_n4 GND_DRV GND_LOGIC nfet L=0.7U W=10U AS=2.1P AD=2.1P PS=10.42U
+ PD=10.42U
* device instance $65 r0 *1 44.45,424.36 nfet
M$65 GND_DRV x2_n4 x2_n5 GND_LOGIC nfet L=0.7U W=10U AS=2.1P AD=2.1P PS=10.42U
+ PD=10.42U
* device instance $66 r0 *1 45.57,424.36 nfet
M$66 x2_n5 x2_n4 GND_DRV GND_LOGIC nfet L=0.7U W=10U AS=2.1P AD=2.1P PS=10.42U
+ PD=10.42U
* device instance $67 r0 *1 46.69,424.36 nfet
M$67 GND_DRV x2_n4 x2_n5 GND_LOGIC nfet L=0.7U W=10U AS=2.1P AD=2.1P PS=10.42U
+ PD=10.42U
* device instance $68 r0 *1 47.81,424.36 nfet
M$68 x2_n5 x2_n4 GND_DRV GND_LOGIC nfet L=0.7U W=10U AS=2.1P AD=2.1P PS=10.42U
+ PD=10.42U
* device instance $69 r0 *1 48.93,424.36 nfet
M$69 GND_DRV x2_n4 x2_n5 GND_LOGIC nfet L=0.7U W=10U AS=2.1P AD=2.1P PS=10.42U
+ PD=10.42U
* device instance $70 r0 *1 50.05,424.36 nfet
M$70 x2_n5 x2_n4 GND_DRV GND_LOGIC nfet L=0.7U W=10U AS=2.1P AD=2.1P PS=10.42U
+ PD=10.42U
* device instance $71 r0 *1 51.17,424.36 nfet
M$71 GND_DRV x2_n4 x2_n5 GND_LOGIC nfet L=0.7U W=10U AS=2.1P AD=2.1P PS=10.42U
+ PD=10.42U
* device instance $72 r0 *1 52.29,424.36 nfet
M$72 x2_n5 x2_n4 GND_DRV GND_LOGIC nfet L=0.7U W=10U AS=2.1P AD=2.1P PS=10.42U
+ PD=10.42U
* device instance $73 r0 *1 53.41,424.36 nfet
M$73 GND_DRV x2_n4 x2_n5 GND_LOGIC nfet L=0.7U W=10U AS=2.1P AD=2.1P PS=10.42U
+ PD=10.42U
* device instance $74 r0 *1 54.53,424.36 nfet
M$74 x2_n5 x2_n4 GND_DRV GND_LOGIC nfet L=0.7U W=10U AS=2.1P AD=2.1P PS=10.42U
+ PD=10.42U
* device instance $75 r0 *1 55.65,424.36 nfet
M$75 GND_DRV x2_n4 x2_n5 GND_LOGIC nfet L=0.7U W=10U AS=2.1P AD=2.1P PS=10.42U
+ PD=10.42U
* device instance $76 r0 *1 56.77,424.36 nfet
M$76 x2_n5 x2_n4 GND_DRV GND_LOGIC nfet L=0.7U W=10U AS=2.1P AD=2.1P PS=10.42U
+ PD=10.42U
* device instance $77 r0 *1 57.89,424.36 nfet
M$77 GND_DRV x2_n4 x2_n5 GND_LOGIC nfet L=0.7U W=10U AS=2.1P AD=2.1P PS=10.42U
+ PD=10.42U
* device instance $78 r0 *1 59.01,424.36 nfet
M$78 x2_n5 x2_n4 GND_DRV GND_LOGIC nfet L=0.7U W=10U AS=2.1P AD=2.1P PS=10.42U
+ PD=10.42U
* device instance $79 r0 *1 60.13,424.36 nfet
M$79 GND_DRV x2_n4 x2_n5 GND_LOGIC nfet L=0.7U W=10U AS=2.1P AD=2.1P PS=10.42U
+ PD=10.42U
* device instance $80 r0 *1 61.25,424.36 nfet
M$80 x2_n5 x2_n4 GND_DRV GND_LOGIC nfet L=0.7U W=10U AS=2.1P AD=4.2P PS=10.42U
+ PD=20.84U
* device instance $81 r0 *1 185.57,455.98 nfet
M$81 GND_DRV x2_n5 OUT GND_LOGIC nfet L=0.7U W=10U AS=2.1P AD=2.1P PS=10.42U
+ PD=10.42U
* device instance $82 r0 *1 186.69,455.98 nfet
M$82 OUT x2_n5 GND_DRV GND_LOGIC nfet L=0.7U W=10U AS=2.1P AD=2.1P PS=10.42U
+ PD=10.42U
* device instance $83 r0 *1 187.81,455.98 nfet
M$83 GND_DRV x2_n5 OUT GND_LOGIC nfet L=0.7U W=10U AS=2.1P AD=2.1P PS=10.42U
+ PD=10.42U
* device instance $84 r0 *1 188.93,455.98 nfet
M$84 OUT x2_n5 GND_DRV GND_LOGIC nfet L=0.7U W=10U AS=2.1P AD=2.1P PS=10.42U
+ PD=10.42U
* device instance $85 r0 *1 190.05,455.98 nfet
M$85 GND_DRV x2_n5 OUT GND_LOGIC nfet L=0.7U W=10U AS=2.1P AD=2.1P PS=10.42U
+ PD=10.42U
* device instance $86 r0 *1 191.17,455.98 nfet
M$86 OUT x2_n5 GND_DRV GND_LOGIC nfet L=0.7U W=10U AS=2.1P AD=2.1P PS=10.42U
+ PD=10.42U
* device instance $87 r0 *1 192.29,455.98 nfet
M$87 GND_DRV x2_n5 OUT GND_LOGIC nfet L=0.7U W=10U AS=2.1P AD=2.1P PS=10.42U
+ PD=10.42U
* device instance $88 r0 *1 193.41,455.98 nfet
M$88 OUT x2_n5 GND_DRV GND_LOGIC nfet L=0.7U W=10U AS=2.1P AD=2.1P PS=10.42U
+ PD=10.42U
* device instance $89 r0 *1 194.53,455.98 nfet
M$89 GND_DRV x2_n5 OUT GND_LOGIC nfet L=0.7U W=10U AS=2.1P AD=2.1P PS=10.42U
+ PD=10.42U
* device instance $90 r0 *1 195.65,455.98 nfet
M$90 OUT x2_n5 GND_DRV GND_LOGIC nfet L=0.7U W=10U AS=2.1P AD=2.1P PS=10.42U
+ PD=10.42U
* device instance $91 r0 *1 196.77,455.98 nfet
M$91 GND_DRV x2_n5 OUT GND_LOGIC nfet L=0.7U W=10U AS=2.1P AD=2.1P PS=10.42U
+ PD=10.42U
* device instance $92 r0 *1 197.89,455.98 nfet
M$92 OUT x2_n5 GND_DRV GND_LOGIC nfet L=0.7U W=10U AS=2.1P AD=2.1P PS=10.42U
+ PD=10.42U
* device instance $93 r0 *1 199.01,455.98 nfet
M$93 GND_DRV x2_n5 OUT GND_LOGIC nfet L=0.7U W=10U AS=2.1P AD=2.1P PS=10.42U
+ PD=10.42U
* device instance $94 r0 *1 200.13,455.98 nfet
M$94 OUT x2_n5 GND_DRV GND_LOGIC nfet L=0.7U W=10U AS=2.1P AD=2.1P PS=10.42U
+ PD=10.42U
* device instance $95 r0 *1 201.25,455.98 nfet
M$95 GND_DRV x2_n5 OUT GND_LOGIC nfet L=0.7U W=10U AS=2.1P AD=2.1P PS=10.42U
+ PD=10.42U
* device instance $96 r0 *1 202.37,455.98 nfet
M$96 OUT x2_n5 GND_DRV GND_LOGIC nfet L=0.7U W=10U AS=2.1P AD=2.1P PS=10.42U
+ PD=10.42U
* device instance $97 r0 *1 203.49,455.98 nfet
M$97 GND_DRV x2_n5 OUT GND_LOGIC nfet L=0.7U W=10U AS=2.1P AD=2.1P PS=10.42U
+ PD=10.42U
* device instance $98 r0 *1 204.61,455.98 nfet
M$98 OUT x2_n5 GND_DRV GND_LOGIC nfet L=0.7U W=10U AS=2.1P AD=2.1P PS=10.42U
+ PD=10.42U
* device instance $99 r0 *1 205.73,455.98 nfet
M$99 GND_DRV x2_n5 OUT GND_LOGIC nfet L=0.7U W=10U AS=2.1P AD=2.1P PS=10.42U
+ PD=10.42U
* device instance $100 r0 *1 206.85,455.98 nfet
M$100 OUT x2_n5 GND_DRV GND_LOGIC nfet L=0.7U W=10U AS=2.1P AD=2.1P PS=10.42U
+ PD=10.42U
* device instance $101 r0 *1 207.97,455.98 nfet
M$101 GND_DRV x2_n5 OUT GND_LOGIC nfet L=0.7U W=10U AS=2.1P AD=2.1P PS=10.42U
+ PD=10.42U
* device instance $102 r0 *1 209.09,455.98 nfet
M$102 OUT x2_n5 GND_DRV GND_LOGIC nfet L=0.7U W=10U AS=2.1P AD=2.1P PS=10.42U
+ PD=10.42U
* device instance $103 r0 *1 210.21,455.98 nfet
M$103 GND_DRV x2_n5 OUT GND_LOGIC nfet L=0.7U W=10U AS=2.1P AD=2.1P PS=10.42U
+ PD=10.42U
* device instance $104 r0 *1 211.33,455.98 nfet
M$104 OUT x2_n5 GND_DRV GND_LOGIC nfet L=0.7U W=10U AS=2.1P AD=2.1P PS=10.42U
+ PD=10.42U
* device instance $105 r0 *1 212.45,455.98 nfet
M$105 GND_DRV x2_n5 OUT GND_LOGIC nfet L=0.7U W=10U AS=2.1P AD=2.1P PS=10.42U
+ PD=10.42U
* device instance $106 r0 *1 213.57,455.98 nfet
M$106 OUT x2_n5 GND_DRV GND_LOGIC nfet L=0.7U W=10U AS=2.1P AD=2.1P PS=10.42U
+ PD=10.42U
* device instance $107 r0 *1 214.69,455.98 nfet
M$107 GND_DRV x2_n5 OUT GND_LOGIC nfet L=0.7U W=10U AS=2.1P AD=2.1P PS=10.42U
+ PD=10.42U
* device instance $108 r0 *1 215.81,455.98 nfet
M$108 OUT x2_n5 GND_DRV GND_LOGIC nfet L=0.7U W=10U AS=2.1P AD=2.1P PS=10.42U
+ PD=10.42U
* device instance $109 r0 *1 216.93,455.98 nfet
M$109 GND_DRV x2_n5 OUT GND_LOGIC nfet L=0.7U W=10U AS=2.1P AD=2.1P PS=10.42U
+ PD=10.42U
* device instance $110 r0 *1 218.05,455.98 nfet
M$110 OUT x2_n5 GND_DRV GND_LOGIC nfet L=0.7U W=10U AS=2.1P AD=2.1P PS=10.42U
+ PD=10.42U
* device instance $111 r0 *1 219.17,455.98 nfet
M$111 GND_DRV x2_n5 OUT GND_LOGIC nfet L=0.7U W=10U AS=2.1P AD=2.1P PS=10.42U
+ PD=10.42U
* device instance $112 r0 *1 220.29,455.98 nfet
M$112 OUT x2_n5 GND_DRV GND_LOGIC nfet L=0.7U W=10U AS=2.1P AD=2.1P PS=10.42U
+ PD=10.42U
* device instance $113 r0 *1 221.41,455.98 nfet
M$113 GND_DRV x2_n5 OUT GND_LOGIC nfet L=0.7U W=10U AS=2.1P AD=2.1P PS=10.42U
+ PD=10.42U
* device instance $114 r0 *1 222.53,455.98 nfet
M$114 OUT x2_n5 GND_DRV GND_LOGIC nfet L=0.7U W=10U AS=2.1P AD=2.1P PS=10.42U
+ PD=10.42U
* device instance $115 r0 *1 223.65,455.98 nfet
M$115 GND_DRV x2_n5 OUT GND_LOGIC nfet L=0.7U W=10U AS=2.1P AD=2.1P PS=10.42U
+ PD=10.42U
* device instance $116 r0 *1 224.77,455.98 nfet
M$116 OUT x2_n5 GND_DRV GND_LOGIC nfet L=0.7U W=10U AS=2.1P AD=2.1P PS=10.42U
+ PD=10.42U
* device instance $117 r0 *1 225.89,455.98 nfet
M$117 GND_DRV x2_n5 OUT GND_LOGIC nfet L=0.7U W=10U AS=2.1P AD=2.1P PS=10.42U
+ PD=10.42U
* device instance $118 r0 *1 227.01,455.98 nfet
M$118 OUT x2_n5 GND_DRV GND_LOGIC nfet L=0.7U W=10U AS=2.1P AD=2.1P PS=10.42U
+ PD=10.42U
* device instance $119 r0 *1 228.13,455.98 nfet
M$119 GND_DRV x2_n5 OUT GND_LOGIC nfet L=0.7U W=10U AS=2.1P AD=2.1P PS=10.42U
+ PD=10.42U
* device instance $120 r0 *1 229.25,455.98 nfet
M$120 OUT x2_n5 GND_DRV GND_LOGIC nfet L=0.7U W=10U AS=2.1P AD=2.1P PS=10.42U
+ PD=10.42U
* device instance $121 r0 *1 230.37,455.98 nfet
M$121 GND_DRV x2_n5 OUT GND_LOGIC nfet L=0.7U W=10U AS=2.1P AD=2.1P PS=10.42U
+ PD=10.42U
* device instance $122 r0 *1 231.49,455.98 nfet
M$122 OUT x2_n5 GND_DRV GND_LOGIC nfet L=0.7U W=10U AS=2.1P AD=2.1P PS=10.42U
+ PD=10.42U
* device instance $123 r0 *1 232.61,455.98 nfet
M$123 GND_DRV x2_n5 OUT GND_LOGIC nfet L=0.7U W=10U AS=2.1P AD=2.1P PS=10.42U
+ PD=10.42U
* device instance $124 r0 *1 233.73,455.98 nfet
M$124 OUT x2_n5 GND_DRV GND_LOGIC nfet L=0.7U W=10U AS=2.1P AD=2.1P PS=10.42U
+ PD=10.42U
* device instance $125 r0 *1 234.85,455.98 nfet
M$125 GND_DRV x2_n5 OUT GND_LOGIC nfet L=0.7U W=10U AS=2.1P AD=2.1P PS=10.42U
+ PD=10.42U
* device instance $126 r0 *1 235.97,455.98 nfet
M$126 OUT x2_n5 GND_DRV GND_LOGIC nfet L=0.7U W=10U AS=2.1P AD=2.1P PS=10.42U
+ PD=10.42U
* device instance $127 r0 *1 237.09,455.98 nfet
M$127 GND_DRV x2_n5 OUT GND_LOGIC nfet L=0.7U W=10U AS=2.1P AD=2.1P PS=10.42U
+ PD=10.42U
* device instance $128 r0 *1 238.21,455.98 nfet
M$128 OUT x2_n5 GND_DRV GND_LOGIC nfet L=0.7U W=10U AS=2.1P AD=2.1P PS=10.42U
+ PD=10.42U
* device instance $129 r0 *1 239.33,455.98 nfet
M$129 GND_DRV x2_n5 OUT GND_LOGIC nfet L=0.7U W=10U AS=2.1P AD=2.1P PS=10.42U
+ PD=10.42U
* device instance $130 r0 *1 240.45,455.98 nfet
M$130 OUT x2_n5 GND_DRV GND_LOGIC nfet L=0.7U W=10U AS=2.1P AD=2.1P PS=10.42U
+ PD=10.42U
* device instance $131 r0 *1 241.57,455.98 nfet
M$131 GND_DRV x2_n5 OUT GND_LOGIC nfet L=0.7U W=10U AS=2.1P AD=2.1P PS=10.42U
+ PD=10.42U
* device instance $132 r0 *1 242.69,455.98 nfet
M$132 OUT x2_n5 GND_DRV GND_LOGIC nfet L=0.7U W=10U AS=2.1P AD=2.1P PS=10.42U
+ PD=10.42U
* device instance $133 r0 *1 243.81,455.98 nfet
M$133 GND_DRV x2_n5 OUT GND_LOGIC nfet L=0.7U W=10U AS=2.1P AD=2.1P PS=10.42U
+ PD=10.42U
* device instance $134 r0 *1 244.93,455.98 nfet
M$134 OUT x2_n5 GND_DRV GND_LOGIC nfet L=0.7U W=10U AS=2.1P AD=2.1P PS=10.42U
+ PD=10.42U
* device instance $135 r0 *1 246.05,455.98 nfet
M$135 GND_DRV x2_n5 OUT GND_LOGIC nfet L=0.7U W=10U AS=2.1P AD=4.2P PS=10.42U
+ PD=20.84U
* device instance $136 r0 *1 123.97,455.98 nfet
M$136 OUT x2_n5 GND_DRV GND_LOGIC nfet L=0.7U W=10U AS=2.1P AD=2.1P PS=10.42U
+ PD=10.42U
* device instance $137 r0 *1 125.09,455.98 nfet
M$137 GND_DRV x2_n5 OUT GND_LOGIC nfet L=0.7U W=10U AS=2.1P AD=2.1P PS=10.42U
+ PD=10.42U
* device instance $138 r0 *1 126.21,455.98 nfet
M$138 OUT x2_n5 GND_DRV GND_LOGIC nfet L=0.7U W=10U AS=2.1P AD=2.1P PS=10.42U
+ PD=10.42U
* device instance $139 r0 *1 127.33,455.98 nfet
M$139 GND_DRV x2_n5 OUT GND_LOGIC nfet L=0.7U W=10U AS=2.1P AD=2.1P PS=10.42U
+ PD=10.42U
* device instance $140 r0 *1 128.45,455.98 nfet
M$140 OUT x2_n5 GND_DRV GND_LOGIC nfet L=0.7U W=10U AS=2.1P AD=2.1P PS=10.42U
+ PD=10.42U
* device instance $141 r0 *1 129.57,455.98 nfet
M$141 GND_DRV x2_n5 OUT GND_LOGIC nfet L=0.7U W=10U AS=2.1P AD=2.1P PS=10.42U
+ PD=10.42U
* device instance $142 r0 *1 130.69,455.98 nfet
M$142 OUT x2_n5 GND_DRV GND_LOGIC nfet L=0.7U W=10U AS=2.1P AD=2.1P PS=10.42U
+ PD=10.42U
* device instance $143 r0 *1 131.81,455.98 nfet
M$143 GND_DRV x2_n5 OUT GND_LOGIC nfet L=0.7U W=10U AS=2.1P AD=2.1P PS=10.42U
+ PD=10.42U
* device instance $144 r0 *1 132.93,455.98 nfet
M$144 OUT x2_n5 GND_DRV GND_LOGIC nfet L=0.7U W=10U AS=2.1P AD=2.1P PS=10.42U
+ PD=10.42U
* device instance $145 r0 *1 134.05,455.98 nfet
M$145 GND_DRV x2_n5 OUT GND_LOGIC nfet L=0.7U W=10U AS=2.1P AD=2.1P PS=10.42U
+ PD=10.42U
* device instance $146 r0 *1 135.17,455.98 nfet
M$146 OUT x2_n5 GND_DRV GND_LOGIC nfet L=0.7U W=10U AS=2.1P AD=2.1P PS=10.42U
+ PD=10.42U
* device instance $147 r0 *1 136.29,455.98 nfet
M$147 GND_DRV x2_n5 OUT GND_LOGIC nfet L=0.7U W=10U AS=2.1P AD=2.1P PS=10.42U
+ PD=10.42U
* device instance $148 r0 *1 137.41,455.98 nfet
M$148 OUT x2_n5 GND_DRV GND_LOGIC nfet L=0.7U W=10U AS=2.1P AD=2.1P PS=10.42U
+ PD=10.42U
* device instance $149 r0 *1 138.53,455.98 nfet
M$149 GND_DRV x2_n5 OUT GND_LOGIC nfet L=0.7U W=10U AS=2.1P AD=2.1P PS=10.42U
+ PD=10.42U
* device instance $150 r0 *1 139.65,455.98 nfet
M$150 OUT x2_n5 GND_DRV GND_LOGIC nfet L=0.7U W=10U AS=2.1P AD=2.1P PS=10.42U
+ PD=10.42U
* device instance $151 r0 *1 140.77,455.98 nfet
M$151 GND_DRV x2_n5 OUT GND_LOGIC nfet L=0.7U W=10U AS=2.1P AD=2.1P PS=10.42U
+ PD=10.42U
* device instance $152 r0 *1 141.89,455.98 nfet
M$152 OUT x2_n5 GND_DRV GND_LOGIC nfet L=0.7U W=10U AS=2.1P AD=2.1P PS=10.42U
+ PD=10.42U
* device instance $153 r0 *1 143.01,455.98 nfet
M$153 GND_DRV x2_n5 OUT GND_LOGIC nfet L=0.7U W=10U AS=2.1P AD=2.1P PS=10.42U
+ PD=10.42U
* device instance $154 r0 *1 144.13,455.98 nfet
M$154 OUT x2_n5 GND_DRV GND_LOGIC nfet L=0.7U W=10U AS=2.1P AD=2.1P PS=10.42U
+ PD=10.42U
* device instance $155 r0 *1 145.25,455.98 nfet
M$155 GND_DRV x2_n5 OUT GND_LOGIC nfet L=0.7U W=10U AS=2.1P AD=2.1P PS=10.42U
+ PD=10.42U
* device instance $156 r0 *1 146.37,455.98 nfet
M$156 OUT x2_n5 GND_DRV GND_LOGIC nfet L=0.7U W=10U AS=2.1P AD=2.1P PS=10.42U
+ PD=10.42U
* device instance $157 r0 *1 147.49,455.98 nfet
M$157 GND_DRV x2_n5 OUT GND_LOGIC nfet L=0.7U W=10U AS=2.1P AD=2.1P PS=10.42U
+ PD=10.42U
* device instance $158 r0 *1 148.61,455.98 nfet
M$158 OUT x2_n5 GND_DRV GND_LOGIC nfet L=0.7U W=10U AS=2.1P AD=2.1P PS=10.42U
+ PD=10.42U
* device instance $159 r0 *1 149.73,455.98 nfet
M$159 GND_DRV x2_n5 OUT GND_LOGIC nfet L=0.7U W=10U AS=2.1P AD=2.1P PS=10.42U
+ PD=10.42U
* device instance $160 r0 *1 150.85,455.98 nfet
M$160 OUT x2_n5 GND_DRV GND_LOGIC nfet L=0.7U W=10U AS=2.1P AD=2.1P PS=10.42U
+ PD=10.42U
* device instance $161 r0 *1 151.97,455.98 nfet
M$161 GND_DRV x2_n5 OUT GND_LOGIC nfet L=0.7U W=10U AS=2.1P AD=2.1P PS=10.42U
+ PD=10.42U
* device instance $162 r0 *1 153.09,455.98 nfet
M$162 OUT x2_n5 GND_DRV GND_LOGIC nfet L=0.7U W=10U AS=2.1P AD=2.1P PS=10.42U
+ PD=10.42U
* device instance $163 r0 *1 154.21,455.98 nfet
M$163 GND_DRV x2_n5 OUT GND_LOGIC nfet L=0.7U W=10U AS=2.1P AD=2.1P PS=10.42U
+ PD=10.42U
* device instance $164 r0 *1 155.33,455.98 nfet
M$164 OUT x2_n5 GND_DRV GND_LOGIC nfet L=0.7U W=10U AS=2.1P AD=2.1P PS=10.42U
+ PD=10.42U
* device instance $165 r0 *1 156.45,455.98 nfet
M$165 GND_DRV x2_n5 OUT GND_LOGIC nfet L=0.7U W=10U AS=2.1P AD=2.1P PS=10.42U
+ PD=10.42U
* device instance $166 r0 *1 157.57,455.98 nfet
M$166 OUT x2_n5 GND_DRV GND_LOGIC nfet L=0.7U W=10U AS=2.1P AD=2.1P PS=10.42U
+ PD=10.42U
* device instance $167 r0 *1 158.69,455.98 nfet
M$167 GND_DRV x2_n5 OUT GND_LOGIC nfet L=0.7U W=10U AS=2.1P AD=2.1P PS=10.42U
+ PD=10.42U
* device instance $168 r0 *1 159.81,455.98 nfet
M$168 OUT x2_n5 GND_DRV GND_LOGIC nfet L=0.7U W=10U AS=2.1P AD=2.1P PS=10.42U
+ PD=10.42U
* device instance $169 r0 *1 160.93,455.98 nfet
M$169 GND_DRV x2_n5 OUT GND_LOGIC nfet L=0.7U W=10U AS=2.1P AD=2.1P PS=10.42U
+ PD=10.42U
* device instance $170 r0 *1 162.05,455.98 nfet
M$170 OUT x2_n5 GND_DRV GND_LOGIC nfet L=0.7U W=10U AS=2.1P AD=2.1P PS=10.42U
+ PD=10.42U
* device instance $171 r0 *1 163.17,455.98 nfet
M$171 GND_DRV x2_n5 OUT GND_LOGIC nfet L=0.7U W=10U AS=2.1P AD=2.1P PS=10.42U
+ PD=10.42U
* device instance $172 r0 *1 164.29,455.98 nfet
M$172 OUT x2_n5 GND_DRV GND_LOGIC nfet L=0.7U W=10U AS=2.1P AD=2.1P PS=10.42U
+ PD=10.42U
* device instance $173 r0 *1 165.41,455.98 nfet
M$173 GND_DRV x2_n5 OUT GND_LOGIC nfet L=0.7U W=10U AS=2.1P AD=2.1P PS=10.42U
+ PD=10.42U
* device instance $174 r0 *1 166.53,455.98 nfet
M$174 OUT x2_n5 GND_DRV GND_LOGIC nfet L=0.7U W=10U AS=2.1P AD=2.1P PS=10.42U
+ PD=10.42U
* device instance $175 r0 *1 167.65,455.98 nfet
M$175 GND_DRV x2_n5 OUT GND_LOGIC nfet L=0.7U W=10U AS=2.1P AD=2.1P PS=10.42U
+ PD=10.42U
* device instance $176 r0 *1 168.77,455.98 nfet
M$176 OUT x2_n5 GND_DRV GND_LOGIC nfet L=0.7U W=10U AS=2.1P AD=2.1P PS=10.42U
+ PD=10.42U
* device instance $177 r0 *1 169.89,455.98 nfet
M$177 GND_DRV x2_n5 OUT GND_LOGIC nfet L=0.7U W=10U AS=2.1P AD=2.1P PS=10.42U
+ PD=10.42U
* device instance $178 r0 *1 171.01,455.98 nfet
M$178 OUT x2_n5 GND_DRV GND_LOGIC nfet L=0.7U W=10U AS=2.1P AD=2.1P PS=10.42U
+ PD=10.42U
* device instance $179 r0 *1 172.13,455.98 nfet
M$179 GND_DRV x2_n5 OUT GND_LOGIC nfet L=0.7U W=10U AS=2.1P AD=2.1P PS=10.42U
+ PD=10.42U
* device instance $180 r0 *1 173.25,455.98 nfet
M$180 OUT x2_n5 GND_DRV GND_LOGIC nfet L=0.7U W=10U AS=2.1P AD=2.1P PS=10.42U
+ PD=10.42U
* device instance $181 r0 *1 174.37,455.98 nfet
M$181 GND_DRV x2_n5 OUT GND_LOGIC nfet L=0.7U W=10U AS=2.1P AD=2.1P PS=10.42U
+ PD=10.42U
* device instance $182 r0 *1 175.49,455.98 nfet
M$182 OUT x2_n5 GND_DRV GND_LOGIC nfet L=0.7U W=10U AS=2.1P AD=2.1P PS=10.42U
+ PD=10.42U
* device instance $183 r0 *1 176.61,455.98 nfet
M$183 GND_DRV x2_n5 OUT GND_LOGIC nfet L=0.7U W=10U AS=2.1P AD=2.1P PS=10.42U
+ PD=10.42U
* device instance $184 r0 *1 177.73,455.98 nfet
M$184 OUT x2_n5 GND_DRV GND_LOGIC nfet L=0.7U W=10U AS=2.1P AD=2.1P PS=10.42U
+ PD=10.42U
* device instance $185 r0 *1 178.85,455.98 nfet
M$185 GND_DRV x2_n5 OUT GND_LOGIC nfet L=0.7U W=10U AS=2.1P AD=2.1P PS=10.42U
+ PD=10.42U
* device instance $186 r0 *1 179.97,455.98 nfet
M$186 OUT x2_n5 GND_DRV GND_LOGIC nfet L=0.7U W=10U AS=2.1P AD=2.1P PS=10.42U
+ PD=10.42U
* device instance $187 r0 *1 181.09,455.98 nfet
M$187 GND_DRV x2_n5 OUT GND_LOGIC nfet L=0.7U W=10U AS=2.1P AD=2.1P PS=10.42U
+ PD=10.42U
* device instance $188 r0 *1 182.21,455.98 nfet
M$188 OUT x2_n5 GND_DRV GND_LOGIC nfet L=0.7U W=10U AS=2.1P AD=2.1P PS=10.42U
+ PD=10.42U
* device instance $189 r0 *1 183.33,455.98 nfet
M$189 GND_DRV x2_n5 OUT GND_LOGIC nfet L=0.7U W=10U AS=2.1P AD=2.1P PS=10.42U
+ PD=10.42U
* device instance $190 r0 *1 184.45,455.98 nfet
M$190 OUT x2_n5 GND_DRV GND_LOGIC nfet L=0.7U W=10U AS=2.1P AD=2.1P PS=10.42U
+ PD=10.42U
* device instance $191 r0 *1 62.37,455.98 nfet
M$191 GND_DRV x2_n5 OUT GND_LOGIC nfet L=0.7U W=10U AS=2.1P AD=2.1P PS=10.42U
+ PD=10.42U
* device instance $192 r0 *1 63.49,455.98 nfet
M$192 OUT x2_n5 GND_DRV GND_LOGIC nfet L=0.7U W=10U AS=2.1P AD=2.1P PS=10.42U
+ PD=10.42U
* device instance $193 r0 *1 64.61,455.98 nfet
M$193 GND_DRV x2_n5 OUT GND_LOGIC nfet L=0.7U W=10U AS=2.1P AD=2.1P PS=10.42U
+ PD=10.42U
* device instance $194 r0 *1 65.73,455.98 nfet
M$194 OUT x2_n5 GND_DRV GND_LOGIC nfet L=0.7U W=10U AS=2.1P AD=2.1P PS=10.42U
+ PD=10.42U
* device instance $195 r0 *1 66.85,455.98 nfet
M$195 GND_DRV x2_n5 OUT GND_LOGIC nfet L=0.7U W=10U AS=2.1P AD=2.1P PS=10.42U
+ PD=10.42U
* device instance $196 r0 *1 67.97,455.98 nfet
M$196 OUT x2_n5 GND_DRV GND_LOGIC nfet L=0.7U W=10U AS=2.1P AD=2.1P PS=10.42U
+ PD=10.42U
* device instance $197 r0 *1 69.09,455.98 nfet
M$197 GND_DRV x2_n5 OUT GND_LOGIC nfet L=0.7U W=10U AS=2.1P AD=2.1P PS=10.42U
+ PD=10.42U
* device instance $198 r0 *1 70.21,455.98 nfet
M$198 OUT x2_n5 GND_DRV GND_LOGIC nfet L=0.7U W=10U AS=2.1P AD=2.1P PS=10.42U
+ PD=10.42U
* device instance $199 r0 *1 71.33,455.98 nfet
M$199 GND_DRV x2_n5 OUT GND_LOGIC nfet L=0.7U W=10U AS=2.1P AD=2.1P PS=10.42U
+ PD=10.42U
* device instance $200 r0 *1 72.45,455.98 nfet
M$200 OUT x2_n5 GND_DRV GND_LOGIC nfet L=0.7U W=10U AS=2.1P AD=2.1P PS=10.42U
+ PD=10.42U
* device instance $201 r0 *1 73.57,455.98 nfet
M$201 GND_DRV x2_n5 OUT GND_LOGIC nfet L=0.7U W=10U AS=2.1P AD=2.1P PS=10.42U
+ PD=10.42U
* device instance $202 r0 *1 74.69,455.98 nfet
M$202 OUT x2_n5 GND_DRV GND_LOGIC nfet L=0.7U W=10U AS=2.1P AD=2.1P PS=10.42U
+ PD=10.42U
* device instance $203 r0 *1 75.81,455.98 nfet
M$203 GND_DRV x2_n5 OUT GND_LOGIC nfet L=0.7U W=10U AS=2.1P AD=2.1P PS=10.42U
+ PD=10.42U
* device instance $204 r0 *1 76.93,455.98 nfet
M$204 OUT x2_n5 GND_DRV GND_LOGIC nfet L=0.7U W=10U AS=2.1P AD=2.1P PS=10.42U
+ PD=10.42U
* device instance $205 r0 *1 78.05,455.98 nfet
M$205 GND_DRV x2_n5 OUT GND_LOGIC nfet L=0.7U W=10U AS=2.1P AD=2.1P PS=10.42U
+ PD=10.42U
* device instance $206 r0 *1 79.17,455.98 nfet
M$206 OUT x2_n5 GND_DRV GND_LOGIC nfet L=0.7U W=10U AS=2.1P AD=2.1P PS=10.42U
+ PD=10.42U
* device instance $207 r0 *1 80.29,455.98 nfet
M$207 GND_DRV x2_n5 OUT GND_LOGIC nfet L=0.7U W=10U AS=2.1P AD=2.1P PS=10.42U
+ PD=10.42U
* device instance $208 r0 *1 81.41,455.98 nfet
M$208 OUT x2_n5 GND_DRV GND_LOGIC nfet L=0.7U W=10U AS=2.1P AD=2.1P PS=10.42U
+ PD=10.42U
* device instance $209 r0 *1 82.53,455.98 nfet
M$209 GND_DRV x2_n5 OUT GND_LOGIC nfet L=0.7U W=10U AS=2.1P AD=2.1P PS=10.42U
+ PD=10.42U
* device instance $210 r0 *1 83.65,455.98 nfet
M$210 OUT x2_n5 GND_DRV GND_LOGIC nfet L=0.7U W=10U AS=2.1P AD=2.1P PS=10.42U
+ PD=10.42U
* device instance $211 r0 *1 84.77,455.98 nfet
M$211 GND_DRV x2_n5 OUT GND_LOGIC nfet L=0.7U W=10U AS=2.1P AD=2.1P PS=10.42U
+ PD=10.42U
* device instance $212 r0 *1 85.89,455.98 nfet
M$212 OUT x2_n5 GND_DRV GND_LOGIC nfet L=0.7U W=10U AS=2.1P AD=2.1P PS=10.42U
+ PD=10.42U
* device instance $213 r0 *1 87.01,455.98 nfet
M$213 GND_DRV x2_n5 OUT GND_LOGIC nfet L=0.7U W=10U AS=2.1P AD=2.1P PS=10.42U
+ PD=10.42U
* device instance $214 r0 *1 88.13,455.98 nfet
M$214 OUT x2_n5 GND_DRV GND_LOGIC nfet L=0.7U W=10U AS=2.1P AD=2.1P PS=10.42U
+ PD=10.42U
* device instance $215 r0 *1 89.25,455.98 nfet
M$215 GND_DRV x2_n5 OUT GND_LOGIC nfet L=0.7U W=10U AS=2.1P AD=2.1P PS=10.42U
+ PD=10.42U
* device instance $216 r0 *1 90.37,455.98 nfet
M$216 OUT x2_n5 GND_DRV GND_LOGIC nfet L=0.7U W=10U AS=2.1P AD=2.1P PS=10.42U
+ PD=10.42U
* device instance $217 r0 *1 91.49,455.98 nfet
M$217 GND_DRV x2_n5 OUT GND_LOGIC nfet L=0.7U W=10U AS=2.1P AD=2.1P PS=10.42U
+ PD=10.42U
* device instance $218 r0 *1 92.61,455.98 nfet
M$218 OUT x2_n5 GND_DRV GND_LOGIC nfet L=0.7U W=10U AS=2.1P AD=2.1P PS=10.42U
+ PD=10.42U
* device instance $219 r0 *1 93.73,455.98 nfet
M$219 GND_DRV x2_n5 OUT GND_LOGIC nfet L=0.7U W=10U AS=2.1P AD=2.1P PS=10.42U
+ PD=10.42U
* device instance $220 r0 *1 94.85,455.98 nfet
M$220 OUT x2_n5 GND_DRV GND_LOGIC nfet L=0.7U W=10U AS=2.1P AD=2.1P PS=10.42U
+ PD=10.42U
* device instance $221 r0 *1 95.97,455.98 nfet
M$221 GND_DRV x2_n5 OUT GND_LOGIC nfet L=0.7U W=10U AS=2.1P AD=2.1P PS=10.42U
+ PD=10.42U
* device instance $222 r0 *1 97.09,455.98 nfet
M$222 OUT x2_n5 GND_DRV GND_LOGIC nfet L=0.7U W=10U AS=2.1P AD=2.1P PS=10.42U
+ PD=10.42U
* device instance $223 r0 *1 98.21,455.98 nfet
M$223 GND_DRV x2_n5 OUT GND_LOGIC nfet L=0.7U W=10U AS=2.1P AD=2.1P PS=10.42U
+ PD=10.42U
* device instance $224 r0 *1 99.33,455.98 nfet
M$224 OUT x2_n5 GND_DRV GND_LOGIC nfet L=0.7U W=10U AS=2.1P AD=2.1P PS=10.42U
+ PD=10.42U
* device instance $225 r0 *1 100.45,455.98 nfet
M$225 GND_DRV x2_n5 OUT GND_LOGIC nfet L=0.7U W=10U AS=2.1P AD=2.1P PS=10.42U
+ PD=10.42U
* device instance $226 r0 *1 101.57,455.98 nfet
M$226 OUT x2_n5 GND_DRV GND_LOGIC nfet L=0.7U W=10U AS=2.1P AD=2.1P PS=10.42U
+ PD=10.42U
* device instance $227 r0 *1 102.69,455.98 nfet
M$227 GND_DRV x2_n5 OUT GND_LOGIC nfet L=0.7U W=10U AS=2.1P AD=2.1P PS=10.42U
+ PD=10.42U
* device instance $228 r0 *1 103.81,455.98 nfet
M$228 OUT x2_n5 GND_DRV GND_LOGIC nfet L=0.7U W=10U AS=2.1P AD=2.1P PS=10.42U
+ PD=10.42U
* device instance $229 r0 *1 104.93,455.98 nfet
M$229 GND_DRV x2_n5 OUT GND_LOGIC nfet L=0.7U W=10U AS=2.1P AD=2.1P PS=10.42U
+ PD=10.42U
* device instance $230 r0 *1 106.05,455.98 nfet
M$230 OUT x2_n5 GND_DRV GND_LOGIC nfet L=0.7U W=10U AS=2.1P AD=2.1P PS=10.42U
+ PD=10.42U
* device instance $231 r0 *1 107.17,455.98 nfet
M$231 GND_DRV x2_n5 OUT GND_LOGIC nfet L=0.7U W=10U AS=2.1P AD=2.1P PS=10.42U
+ PD=10.42U
* device instance $232 r0 *1 108.29,455.98 nfet
M$232 OUT x2_n5 GND_DRV GND_LOGIC nfet L=0.7U W=10U AS=2.1P AD=2.1P PS=10.42U
+ PD=10.42U
* device instance $233 r0 *1 109.41,455.98 nfet
M$233 GND_DRV x2_n5 OUT GND_LOGIC nfet L=0.7U W=10U AS=2.1P AD=2.1P PS=10.42U
+ PD=10.42U
* device instance $234 r0 *1 110.53,455.98 nfet
M$234 OUT x2_n5 GND_DRV GND_LOGIC nfet L=0.7U W=10U AS=2.1P AD=2.1P PS=10.42U
+ PD=10.42U
* device instance $235 r0 *1 111.65,455.98 nfet
M$235 GND_DRV x2_n5 OUT GND_LOGIC nfet L=0.7U W=10U AS=2.1P AD=2.1P PS=10.42U
+ PD=10.42U
* device instance $236 r0 *1 112.77,455.98 nfet
M$236 OUT x2_n5 GND_DRV GND_LOGIC nfet L=0.7U W=10U AS=2.1P AD=2.1P PS=10.42U
+ PD=10.42U
* device instance $237 r0 *1 113.89,455.98 nfet
M$237 GND_DRV x2_n5 OUT GND_LOGIC nfet L=0.7U W=10U AS=2.1P AD=2.1P PS=10.42U
+ PD=10.42U
* device instance $238 r0 *1 115.01,455.98 nfet
M$238 OUT x2_n5 GND_DRV GND_LOGIC nfet L=0.7U W=10U AS=2.1P AD=2.1P PS=10.42U
+ PD=10.42U
* device instance $239 r0 *1 116.13,455.98 nfet
M$239 GND_DRV x2_n5 OUT GND_LOGIC nfet L=0.7U W=10U AS=2.1P AD=2.1P PS=10.42U
+ PD=10.42U
* device instance $240 r0 *1 117.25,455.98 nfet
M$240 OUT x2_n5 GND_DRV GND_LOGIC nfet L=0.7U W=10U AS=2.1P AD=2.1P PS=10.42U
+ PD=10.42U
* device instance $241 r0 *1 118.37,455.98 nfet
M$241 GND_DRV x2_n5 OUT GND_LOGIC nfet L=0.7U W=10U AS=2.1P AD=2.1P PS=10.42U
+ PD=10.42U
* device instance $242 r0 *1 119.49,455.98 nfet
M$242 OUT x2_n5 GND_DRV GND_LOGIC nfet L=0.7U W=10U AS=2.1P AD=2.1P PS=10.42U
+ PD=10.42U
* device instance $243 r0 *1 120.61,455.98 nfet
M$243 GND_DRV x2_n5 OUT GND_LOGIC nfet L=0.7U W=10U AS=2.1P AD=2.1P PS=10.42U
+ PD=10.42U
* device instance $244 r0 *1 121.73,455.98 nfet
M$244 OUT x2_n5 GND_DRV GND_LOGIC nfet L=0.7U W=10U AS=2.1P AD=2.1P PS=10.42U
+ PD=10.42U
* device instance $245 r0 *1 122.85,455.98 nfet
M$245 GND_DRV x2_n5 OUT GND_LOGIC nfet L=0.7U W=10U AS=2.1P AD=2.1P PS=10.42U
+ PD=10.42U
* device instance $246 r0 *1 0.77,455.98 nfet
M$246 OUT x2_n5 GND_DRV GND_LOGIC nfet L=0.7U W=10U AS=4.2P AD=2.1P PS=20.84U
+ PD=10.42U
* device instance $247 r0 *1 1.89,455.98 nfet
M$247 GND_DRV x2_n5 OUT GND_LOGIC nfet L=0.7U W=10U AS=2.1P AD=2.1P PS=10.42U
+ PD=10.42U
* device instance $248 r0 *1 3.01,455.98 nfet
M$248 OUT x2_n5 GND_DRV GND_LOGIC nfet L=0.7U W=10U AS=2.1P AD=2.1P PS=10.42U
+ PD=10.42U
* device instance $249 r0 *1 4.13,455.98 nfet
M$249 GND_DRV x2_n5 OUT GND_LOGIC nfet L=0.7U W=10U AS=2.1P AD=2.1P PS=10.42U
+ PD=10.42U
* device instance $250 r0 *1 5.25,455.98 nfet
M$250 OUT x2_n5 GND_DRV GND_LOGIC nfet L=0.7U W=10U AS=2.1P AD=2.1P PS=10.42U
+ PD=10.42U
* device instance $251 r0 *1 6.37,455.98 nfet
M$251 GND_DRV x2_n5 OUT GND_LOGIC nfet L=0.7U W=10U AS=2.1P AD=2.1P PS=10.42U
+ PD=10.42U
* device instance $252 r0 *1 7.49,455.98 nfet
M$252 OUT x2_n5 GND_DRV GND_LOGIC nfet L=0.7U W=10U AS=2.1P AD=2.1P PS=10.42U
+ PD=10.42U
* device instance $253 r0 *1 8.61,455.98 nfet
M$253 GND_DRV x2_n5 OUT GND_LOGIC nfet L=0.7U W=10U AS=2.1P AD=2.1P PS=10.42U
+ PD=10.42U
* device instance $254 r0 *1 9.73,455.98 nfet
M$254 OUT x2_n5 GND_DRV GND_LOGIC nfet L=0.7U W=10U AS=2.1P AD=2.1P PS=10.42U
+ PD=10.42U
* device instance $255 r0 *1 10.85,455.98 nfet
M$255 GND_DRV x2_n5 OUT GND_LOGIC nfet L=0.7U W=10U AS=2.1P AD=2.1P PS=10.42U
+ PD=10.42U
* device instance $256 r0 *1 11.97,455.98 nfet
M$256 OUT x2_n5 GND_DRV GND_LOGIC nfet L=0.7U W=10U AS=2.1P AD=2.1P PS=10.42U
+ PD=10.42U
* device instance $257 r0 *1 13.09,455.98 nfet
M$257 GND_DRV x2_n5 OUT GND_LOGIC nfet L=0.7U W=10U AS=2.1P AD=2.1P PS=10.42U
+ PD=10.42U
* device instance $258 r0 *1 14.21,455.98 nfet
M$258 OUT x2_n5 GND_DRV GND_LOGIC nfet L=0.7U W=10U AS=2.1P AD=2.1P PS=10.42U
+ PD=10.42U
* device instance $259 r0 *1 15.33,455.98 nfet
M$259 GND_DRV x2_n5 OUT GND_LOGIC nfet L=0.7U W=10U AS=2.1P AD=2.1P PS=10.42U
+ PD=10.42U
* device instance $260 r0 *1 16.45,455.98 nfet
M$260 OUT x2_n5 GND_DRV GND_LOGIC nfet L=0.7U W=10U AS=2.1P AD=2.1P PS=10.42U
+ PD=10.42U
* device instance $261 r0 *1 17.57,455.98 nfet
M$261 GND_DRV x2_n5 OUT GND_LOGIC nfet L=0.7U W=10U AS=2.1P AD=2.1P PS=10.42U
+ PD=10.42U
* device instance $262 r0 *1 18.69,455.98 nfet
M$262 OUT x2_n5 GND_DRV GND_LOGIC nfet L=0.7U W=10U AS=2.1P AD=2.1P PS=10.42U
+ PD=10.42U
* device instance $263 r0 *1 19.81,455.98 nfet
M$263 GND_DRV x2_n5 OUT GND_LOGIC nfet L=0.7U W=10U AS=2.1P AD=2.1P PS=10.42U
+ PD=10.42U
* device instance $264 r0 *1 20.93,455.98 nfet
M$264 OUT x2_n5 GND_DRV GND_LOGIC nfet L=0.7U W=10U AS=2.1P AD=2.1P PS=10.42U
+ PD=10.42U
* device instance $265 r0 *1 22.05,455.98 nfet
M$265 GND_DRV x2_n5 OUT GND_LOGIC nfet L=0.7U W=10U AS=2.1P AD=2.1P PS=10.42U
+ PD=10.42U
* device instance $266 r0 *1 23.17,455.98 nfet
M$266 OUT x2_n5 GND_DRV GND_LOGIC nfet L=0.7U W=10U AS=2.1P AD=2.1P PS=10.42U
+ PD=10.42U
* device instance $267 r0 *1 24.29,455.98 nfet
M$267 GND_DRV x2_n5 OUT GND_LOGIC nfet L=0.7U W=10U AS=2.1P AD=2.1P PS=10.42U
+ PD=10.42U
* device instance $268 r0 *1 25.41,455.98 nfet
M$268 OUT x2_n5 GND_DRV GND_LOGIC nfet L=0.7U W=10U AS=2.1P AD=2.1P PS=10.42U
+ PD=10.42U
* device instance $269 r0 *1 26.53,455.98 nfet
M$269 GND_DRV x2_n5 OUT GND_LOGIC nfet L=0.7U W=10U AS=2.1P AD=2.1P PS=10.42U
+ PD=10.42U
* device instance $270 r0 *1 27.65,455.98 nfet
M$270 OUT x2_n5 GND_DRV GND_LOGIC nfet L=0.7U W=10U AS=2.1P AD=2.1P PS=10.42U
+ PD=10.42U
* device instance $271 r0 *1 28.77,455.98 nfet
M$271 GND_DRV x2_n5 OUT GND_LOGIC nfet L=0.7U W=10U AS=2.1P AD=2.1P PS=10.42U
+ PD=10.42U
* device instance $272 r0 *1 29.89,455.98 nfet
M$272 OUT x2_n5 GND_DRV GND_LOGIC nfet L=0.7U W=10U AS=2.1P AD=2.1P PS=10.42U
+ PD=10.42U
* device instance $273 r0 *1 31.01,455.98 nfet
M$273 GND_DRV x2_n5 OUT GND_LOGIC nfet L=0.7U W=10U AS=2.1P AD=2.1P PS=10.42U
+ PD=10.42U
* device instance $274 r0 *1 32.13,455.98 nfet
M$274 OUT x2_n5 GND_DRV GND_LOGIC nfet L=0.7U W=10U AS=2.1P AD=2.1P PS=10.42U
+ PD=10.42U
* device instance $275 r0 *1 33.25,455.98 nfet
M$275 GND_DRV x2_n5 OUT GND_LOGIC nfet L=0.7U W=10U AS=2.1P AD=2.1P PS=10.42U
+ PD=10.42U
* device instance $276 r0 *1 34.37,455.98 nfet
M$276 OUT x2_n5 GND_DRV GND_LOGIC nfet L=0.7U W=10U AS=2.1P AD=2.1P PS=10.42U
+ PD=10.42U
* device instance $277 r0 *1 35.49,455.98 nfet
M$277 GND_DRV x2_n5 OUT GND_LOGIC nfet L=0.7U W=10U AS=2.1P AD=2.1P PS=10.42U
+ PD=10.42U
* device instance $278 r0 *1 36.61,455.98 nfet
M$278 OUT x2_n5 GND_DRV GND_LOGIC nfet L=0.7U W=10U AS=2.1P AD=2.1P PS=10.42U
+ PD=10.42U
* device instance $279 r0 *1 37.73,455.98 nfet
M$279 GND_DRV x2_n5 OUT GND_LOGIC nfet L=0.7U W=10U AS=2.1P AD=2.1P PS=10.42U
+ PD=10.42U
* device instance $280 r0 *1 38.85,455.98 nfet
M$280 OUT x2_n5 GND_DRV GND_LOGIC nfet L=0.7U W=10U AS=2.1P AD=2.1P PS=10.42U
+ PD=10.42U
* device instance $281 r0 *1 39.97,455.98 nfet
M$281 GND_DRV x2_n5 OUT GND_LOGIC nfet L=0.7U W=10U AS=2.1P AD=2.1P PS=10.42U
+ PD=10.42U
* device instance $282 r0 *1 41.09,455.98 nfet
M$282 OUT x2_n5 GND_DRV GND_LOGIC nfet L=0.7U W=10U AS=2.1P AD=2.1P PS=10.42U
+ PD=10.42U
* device instance $283 r0 *1 42.21,455.98 nfet
M$283 GND_DRV x2_n5 OUT GND_LOGIC nfet L=0.7U W=10U AS=2.1P AD=2.1P PS=10.42U
+ PD=10.42U
* device instance $284 r0 *1 43.33,455.98 nfet
M$284 OUT x2_n5 GND_DRV GND_LOGIC nfet L=0.7U W=10U AS=2.1P AD=2.1P PS=10.42U
+ PD=10.42U
* device instance $285 r0 *1 44.45,455.98 nfet
M$285 GND_DRV x2_n5 OUT GND_LOGIC nfet L=0.7U W=10U AS=2.1P AD=2.1P PS=10.42U
+ PD=10.42U
* device instance $286 r0 *1 45.57,455.98 nfet
M$286 OUT x2_n5 GND_DRV GND_LOGIC nfet L=0.7U W=10U AS=2.1P AD=2.1P PS=10.42U
+ PD=10.42U
* device instance $287 r0 *1 46.69,455.98 nfet
M$287 GND_DRV x2_n5 OUT GND_LOGIC nfet L=0.7U W=10U AS=2.1P AD=2.1P PS=10.42U
+ PD=10.42U
* device instance $288 r0 *1 47.81,455.98 nfet
M$288 OUT x2_n5 GND_DRV GND_LOGIC nfet L=0.7U W=10U AS=2.1P AD=2.1P PS=10.42U
+ PD=10.42U
* device instance $289 r0 *1 48.93,455.98 nfet
M$289 GND_DRV x2_n5 OUT GND_LOGIC nfet L=0.7U W=10U AS=2.1P AD=2.1P PS=10.42U
+ PD=10.42U
* device instance $290 r0 *1 50.05,455.98 nfet
M$290 OUT x2_n5 GND_DRV GND_LOGIC nfet L=0.7U W=10U AS=2.1P AD=2.1P PS=10.42U
+ PD=10.42U
* device instance $291 r0 *1 51.17,455.98 nfet
M$291 GND_DRV x2_n5 OUT GND_LOGIC nfet L=0.7U W=10U AS=2.1P AD=2.1P PS=10.42U
+ PD=10.42U
* device instance $292 r0 *1 52.29,455.98 nfet
M$292 OUT x2_n5 GND_DRV GND_LOGIC nfet L=0.7U W=10U AS=2.1P AD=2.1P PS=10.42U
+ PD=10.42U
* device instance $293 r0 *1 53.41,455.98 nfet
M$293 GND_DRV x2_n5 OUT GND_LOGIC nfet L=0.7U W=10U AS=2.1P AD=2.1P PS=10.42U
+ PD=10.42U
* device instance $294 r0 *1 54.53,455.98 nfet
M$294 OUT x2_n5 GND_DRV GND_LOGIC nfet L=0.7U W=10U AS=2.1P AD=2.1P PS=10.42U
+ PD=10.42U
* device instance $295 r0 *1 55.65,455.98 nfet
M$295 GND_DRV x2_n5 OUT GND_LOGIC nfet L=0.7U W=10U AS=2.1P AD=2.1P PS=10.42U
+ PD=10.42U
* device instance $296 r0 *1 56.77,455.98 nfet
M$296 OUT x2_n5 GND_DRV GND_LOGIC nfet L=0.7U W=10U AS=2.1P AD=2.1P PS=10.42U
+ PD=10.42U
* device instance $297 r0 *1 57.89,455.98 nfet
M$297 GND_DRV x2_n5 OUT GND_LOGIC nfet L=0.7U W=10U AS=2.1P AD=2.1P PS=10.42U
+ PD=10.42U
* device instance $298 r0 *1 59.01,455.98 nfet
M$298 OUT x2_n5 GND_DRV GND_LOGIC nfet L=0.7U W=10U AS=2.1P AD=2.1P PS=10.42U
+ PD=10.42U
* device instance $299 r0 *1 60.13,455.98 nfet
M$299 GND_DRV x2_n5 OUT GND_LOGIC nfet L=0.7U W=10U AS=2.1P AD=2.1P PS=10.42U
+ PD=10.42U
* device instance $300 r0 *1 61.25,455.98 nfet
M$300 OUT x2_n5 GND_DRV GND_LOGIC nfet L=0.7U W=10U AS=2.1P AD=2.1P PS=10.42U
+ PD=10.42U
* device instance $301 r0 *1 0.77,597.36 nfet
M$301 x3_lockout x3_ncompn GND_DRV GND_LOGIC nfet L=0.7U W=5U AS=2.1P AD=2.1P
+ PS=10.84U PD=10.84U
* device instance $302 r0 *1 784.77,648.04 nfet
M$302 OUT x3_lockout GND_DRV GND_LOGIC nfet L=0.7U W=10U AS=2.1P AD=2.1P
+ PS=10.42U PD=10.42U
* device instance $303 r0 *1 785.89,648.04 nfet
M$303 GND_DRV x3_lockout OUT GND_LOGIC nfet L=0.7U W=10U AS=2.1P AD=2.1P
+ PS=10.42U PD=10.42U
* device instance $304 r0 *1 787.01,648.04 nfet
M$304 OUT x3_lockout GND_DRV GND_LOGIC nfet L=0.7U W=10U AS=2.1P AD=2.1P
+ PS=10.42U PD=10.42U
* device instance $305 r0 *1 788.13,648.04 nfet
M$305 GND_DRV x3_lockout OUT GND_LOGIC nfet L=0.7U W=10U AS=2.1P AD=2.1P
+ PS=10.42U PD=10.42U
* device instance $306 r0 *1 789.25,648.04 nfet
M$306 OUT x3_lockout GND_DRV GND_LOGIC nfet L=0.7U W=10U AS=2.1P AD=2.1P
+ PS=10.42U PD=10.42U
* device instance $307 r0 *1 790.37,648.04 nfet
M$307 GND_DRV x3_lockout OUT GND_LOGIC nfet L=0.7U W=10U AS=2.1P AD=2.1P
+ PS=10.42U PD=10.42U
* device instance $308 r0 *1 791.49,648.04 nfet
M$308 OUT x3_lockout GND_DRV GND_LOGIC nfet L=0.7U W=10U AS=2.1P AD=2.1P
+ PS=10.42U PD=10.42U
* device instance $309 r0 *1 792.61,648.04 nfet
M$309 GND_DRV x3_lockout OUT GND_LOGIC nfet L=0.7U W=10U AS=2.1P AD=2.1P
+ PS=10.42U PD=10.42U
* device instance $310 r0 *1 793.73,648.04 nfet
M$310 OUT x3_lockout GND_DRV GND_LOGIC nfet L=0.7U W=10U AS=2.1P AD=2.1P
+ PS=10.42U PD=10.42U
* device instance $311 r0 *1 794.85,648.04 nfet
M$311 GND_DRV x3_lockout OUT GND_LOGIC nfet L=0.7U W=10U AS=2.1P AD=2.1P
+ PS=10.42U PD=10.42U
* device instance $312 r0 *1 795.97,648.04 nfet
M$312 OUT x3_lockout GND_DRV GND_LOGIC nfet L=0.7U W=10U AS=2.1P AD=2.1P
+ PS=10.42U PD=10.42U
* device instance $313 r0 *1 797.09,648.04 nfet
M$313 GND_DRV x3_lockout OUT GND_LOGIC nfet L=0.7U W=10U AS=2.1P AD=2.1P
+ PS=10.42U PD=10.42U
* device instance $314 r0 *1 798.21,648.04 nfet
M$314 OUT x3_lockout GND_DRV GND_LOGIC nfet L=0.7U W=10U AS=2.1P AD=2.1P
+ PS=10.42U PD=10.42U
* device instance $315 r0 *1 799.33,648.04 nfet
M$315 GND_DRV x3_lockout OUT GND_LOGIC nfet L=0.7U W=10U AS=2.1P AD=2.1P
+ PS=10.42U PD=10.42U
* device instance $316 r0 *1 800.45,648.04 nfet
M$316 OUT x3_lockout GND_DRV GND_LOGIC nfet L=0.7U W=10U AS=2.1P AD=2.1P
+ PS=10.42U PD=10.42U
* device instance $317 r0 *1 801.57,648.04 nfet
M$317 GND_DRV x3_lockout OUT GND_LOGIC nfet L=0.7U W=10U AS=2.1P AD=2.1P
+ PS=10.42U PD=10.42U
* device instance $318 r0 *1 802.69,648.04 nfet
M$318 OUT x3_lockout GND_DRV GND_LOGIC nfet L=0.7U W=10U AS=2.1P AD=2.1P
+ PS=10.42U PD=10.42U
* device instance $319 r0 *1 803.81,648.04 nfet
M$319 GND_DRV x3_lockout OUT GND_LOGIC nfet L=0.7U W=10U AS=2.1P AD=2.1P
+ PS=10.42U PD=10.42U
* device instance $320 r0 *1 804.93,648.04 nfet
M$320 OUT x3_lockout GND_DRV GND_LOGIC nfet L=0.7U W=10U AS=2.1P AD=2.1P
+ PS=10.42U PD=10.42U
* device instance $321 r0 *1 806.05,648.04 nfet
M$321 GND_DRV x3_lockout OUT GND_LOGIC nfet L=0.7U W=10U AS=2.1P AD=2.1P
+ PS=10.42U PD=10.42U
* device instance $322 r0 *1 807.17,648.04 nfet
M$322 OUT x3_lockout GND_DRV GND_LOGIC nfet L=0.7U W=10U AS=2.1P AD=2.1P
+ PS=10.42U PD=10.42U
* device instance $323 r0 *1 808.29,648.04 nfet
M$323 GND_DRV x3_lockout OUT GND_LOGIC nfet L=0.7U W=10U AS=2.1P AD=2.1P
+ PS=10.42U PD=10.42U
* device instance $324 r0 *1 809.41,648.04 nfet
M$324 OUT x3_lockout GND_DRV GND_LOGIC nfet L=0.7U W=10U AS=2.1P AD=2.1P
+ PS=10.42U PD=10.42U
* device instance $325 r0 *1 810.53,648.04 nfet
M$325 GND_DRV x3_lockout OUT GND_LOGIC nfet L=0.7U W=10U AS=2.1P AD=2.1P
+ PS=10.42U PD=10.42U
* device instance $326 r0 *1 811.65,648.04 nfet
M$326 OUT x3_lockout GND_DRV GND_LOGIC nfet L=0.7U W=10U AS=2.1P AD=2.1P
+ PS=10.42U PD=10.42U
* device instance $327 r0 *1 812.77,648.04 nfet
M$327 GND_DRV x3_lockout OUT GND_LOGIC nfet L=0.7U W=10U AS=2.1P AD=2.1P
+ PS=10.42U PD=10.42U
* device instance $328 r0 *1 813.89,648.04 nfet
M$328 OUT x3_lockout GND_DRV GND_LOGIC nfet L=0.7U W=10U AS=2.1P AD=2.1P
+ PS=10.42U PD=10.42U
* device instance $329 r0 *1 815.01,648.04 nfet
M$329 GND_DRV x3_lockout OUT GND_LOGIC nfet L=0.7U W=10U AS=2.1P AD=2.1P
+ PS=10.42U PD=10.42U
* device instance $330 r0 *1 816.13,648.04 nfet
M$330 OUT x3_lockout GND_DRV GND_LOGIC nfet L=0.7U W=10U AS=2.1P AD=2.1P
+ PS=10.42U PD=10.42U
* device instance $331 r0 *1 817.25,648.04 nfet
M$331 GND_DRV x3_lockout OUT GND_LOGIC nfet L=0.7U W=10U AS=2.1P AD=2.1P
+ PS=10.42U PD=10.42U
* device instance $332 r0 *1 818.37,648.04 nfet
M$332 OUT x3_lockout GND_DRV GND_LOGIC nfet L=0.7U W=10U AS=2.1P AD=2.1P
+ PS=10.42U PD=10.42U
* device instance $333 r0 *1 819.49,648.04 nfet
M$333 GND_DRV x3_lockout OUT GND_LOGIC nfet L=0.7U W=10U AS=2.1P AD=2.1P
+ PS=10.42U PD=10.42U
* device instance $334 r0 *1 820.61,648.04 nfet
M$334 OUT x3_lockout GND_DRV GND_LOGIC nfet L=0.7U W=10U AS=2.1P AD=2.1P
+ PS=10.42U PD=10.42U
* device instance $335 r0 *1 821.73,648.04 nfet
M$335 GND_DRV x3_lockout OUT GND_LOGIC nfet L=0.7U W=10U AS=2.1P AD=2.1P
+ PS=10.42U PD=10.42U
* device instance $336 r0 *1 822.85,648.04 nfet
M$336 OUT x3_lockout GND_DRV GND_LOGIC nfet L=0.7U W=10U AS=2.1P AD=2.1P
+ PS=10.42U PD=10.42U
* device instance $337 r0 *1 823.97,648.04 nfet
M$337 GND_DRV x3_lockout OUT GND_LOGIC nfet L=0.7U W=10U AS=2.1P AD=2.1P
+ PS=10.42U PD=10.42U
* device instance $338 r0 *1 825.09,648.04 nfet
M$338 OUT x3_lockout GND_DRV GND_LOGIC nfet L=0.7U W=10U AS=2.1P AD=2.1P
+ PS=10.42U PD=10.42U
* device instance $339 r0 *1 826.21,648.04 nfet
M$339 GND_DRV x3_lockout OUT GND_LOGIC nfet L=0.7U W=10U AS=2.1P AD=2.1P
+ PS=10.42U PD=10.42U
* device instance $340 r0 *1 827.33,648.04 nfet
M$340 OUT x3_lockout GND_DRV GND_LOGIC nfet L=0.7U W=10U AS=2.1P AD=2.1P
+ PS=10.42U PD=10.42U
* device instance $341 r0 *1 828.45,648.04 nfet
M$341 GND_DRV x3_lockout OUT GND_LOGIC nfet L=0.7U W=10U AS=2.1P AD=2.1P
+ PS=10.42U PD=10.42U
* device instance $342 r0 *1 829.57,648.04 nfet
M$342 OUT x3_lockout GND_DRV GND_LOGIC nfet L=0.7U W=10U AS=2.1P AD=2.1P
+ PS=10.42U PD=10.42U
* device instance $343 r0 *1 830.69,648.04 nfet
M$343 GND_DRV x3_lockout OUT GND_LOGIC nfet L=0.7U W=10U AS=2.1P AD=2.1P
+ PS=10.42U PD=10.42U
* device instance $344 r0 *1 831.81,648.04 nfet
M$344 OUT x3_lockout GND_DRV GND_LOGIC nfet L=0.7U W=10U AS=2.1P AD=2.1P
+ PS=10.42U PD=10.42U
* device instance $345 r0 *1 832.93,648.04 nfet
M$345 GND_DRV x3_lockout OUT GND_LOGIC nfet L=0.7U W=10U AS=2.1P AD=2.1P
+ PS=10.42U PD=10.42U
* device instance $346 r0 *1 834.05,648.04 nfet
M$346 OUT x3_lockout GND_DRV GND_LOGIC nfet L=0.7U W=10U AS=2.1P AD=2.1P
+ PS=10.42U PD=10.42U
* device instance $347 r0 *1 835.17,648.04 nfet
M$347 GND_DRV x3_lockout OUT GND_LOGIC nfet L=0.7U W=10U AS=2.1P AD=2.1P
+ PS=10.42U PD=10.42U
* device instance $348 r0 *1 836.29,648.04 nfet
M$348 OUT x3_lockout GND_DRV GND_LOGIC nfet L=0.7U W=10U AS=2.1P AD=2.1P
+ PS=10.42U PD=10.42U
* device instance $349 r0 *1 837.41,648.04 nfet
M$349 GND_DRV x3_lockout OUT GND_LOGIC nfet L=0.7U W=10U AS=2.1P AD=2.1P
+ PS=10.42U PD=10.42U
* device instance $350 r0 *1 838.53,648.04 nfet
M$350 OUT x3_lockout GND_DRV GND_LOGIC nfet L=0.7U W=10U AS=2.1P AD=2.1P
+ PS=10.42U PD=10.42U
* device instance $351 r0 *1 839.65,648.04 nfet
M$351 GND_DRV x3_lockout OUT GND_LOGIC nfet L=0.7U W=10U AS=2.1P AD=2.1P
+ PS=10.42U PD=10.42U
* device instance $352 r0 *1 840.77,648.04 nfet
M$352 OUT x3_lockout GND_DRV GND_LOGIC nfet L=0.7U W=10U AS=2.1P AD=2.1P
+ PS=10.42U PD=10.42U
* device instance $353 r0 *1 841.89,648.04 nfet
M$353 GND_DRV x3_lockout OUT GND_LOGIC nfet L=0.7U W=10U AS=2.1P AD=2.1P
+ PS=10.42U PD=10.42U
* device instance $354 r0 *1 843.01,648.04 nfet
M$354 OUT x3_lockout GND_DRV GND_LOGIC nfet L=0.7U W=10U AS=2.1P AD=2.1P
+ PS=10.42U PD=10.42U
* device instance $355 r0 *1 844.13,648.04 nfet
M$355 GND_DRV x3_lockout OUT GND_LOGIC nfet L=0.7U W=10U AS=2.1P AD=2.1P
+ PS=10.42U PD=10.42U
* device instance $356 r0 *1 845.25,648.04 nfet
M$356 OUT x3_lockout GND_DRV GND_LOGIC nfet L=0.7U W=10U AS=2.1P AD=2.1P
+ PS=10.42U PD=10.42U
* device instance $357 r0 *1 846.37,648.04 nfet
M$357 GND_DRV x3_lockout OUT GND_LOGIC nfet L=0.7U W=10U AS=2.1P AD=2.1P
+ PS=10.42U PD=10.42U
* device instance $358 r0 *1 847.49,648.04 nfet
M$358 OUT x3_lockout GND_DRV GND_LOGIC nfet L=0.7U W=10U AS=2.1P AD=2.1P
+ PS=10.42U PD=10.42U
* device instance $359 r0 *1 848.61,648.04 nfet
M$359 GND_DRV x3_lockout OUT GND_LOGIC nfet L=0.7U W=10U AS=2.1P AD=2.1P
+ PS=10.42U PD=10.42U
* device instance $360 r0 *1 849.73,648.04 nfet
M$360 OUT x3_lockout GND_DRV GND_LOGIC nfet L=0.7U W=10U AS=2.1P AD=2.1P
+ PS=10.42U PD=10.42U
* device instance $361 r0 *1 850.85,648.04 nfet
M$361 GND_DRV x3_lockout OUT GND_LOGIC nfet L=0.7U W=10U AS=2.1P AD=2.1P
+ PS=10.42U PD=10.42U
* device instance $362 r0 *1 851.97,648.04 nfet
M$362 OUT x3_lockout GND_DRV GND_LOGIC nfet L=0.7U W=10U AS=2.1P AD=2.1P
+ PS=10.42U PD=10.42U
* device instance $363 r0 *1 853.09,648.04 nfet
M$363 GND_DRV x3_lockout OUT GND_LOGIC nfet L=0.7U W=10U AS=2.1P AD=2.1P
+ PS=10.42U PD=10.42U
* device instance $364 r0 *1 854.21,648.04 nfet
M$364 OUT x3_lockout GND_DRV GND_LOGIC nfet L=0.7U W=10U AS=2.1P AD=2.1P
+ PS=10.42U PD=10.42U
* device instance $365 r0 *1 855.33,648.04 nfet
M$365 GND_DRV x3_lockout OUT GND_LOGIC nfet L=0.7U W=10U AS=2.1P AD=2.1P
+ PS=10.42U PD=10.42U
* device instance $366 r0 *1 856.45,648.04 nfet
M$366 OUT x3_lockout GND_DRV GND_LOGIC nfet L=0.7U W=10U AS=2.1P AD=2.1P
+ PS=10.42U PD=10.42U
* device instance $367 r0 *1 857.57,648.04 nfet
M$367 GND_DRV x3_lockout OUT GND_LOGIC nfet L=0.7U W=10U AS=2.1P AD=2.1P
+ PS=10.42U PD=10.42U
* device instance $368 r0 *1 858.69,648.04 nfet
M$368 OUT x3_lockout GND_DRV GND_LOGIC nfet L=0.7U W=10U AS=2.1P AD=2.1P
+ PS=10.42U PD=10.42U
* device instance $369 r0 *1 859.81,648.04 nfet
M$369 GND_DRV x3_lockout OUT GND_LOGIC nfet L=0.7U W=10U AS=2.1P AD=2.1P
+ PS=10.42U PD=10.42U
* device instance $370 r0 *1 860.93,648.04 nfet
M$370 OUT x3_lockout GND_DRV GND_LOGIC nfet L=0.7U W=10U AS=2.1P AD=2.1P
+ PS=10.42U PD=10.42U
* device instance $371 r0 *1 862.05,648.04 nfet
M$371 GND_DRV x3_lockout OUT GND_LOGIC nfet L=0.7U W=10U AS=2.1P AD=2.1P
+ PS=10.42U PD=10.42U
* device instance $372 r0 *1 863.17,648.04 nfet
M$372 OUT x3_lockout GND_DRV GND_LOGIC nfet L=0.7U W=10U AS=2.1P AD=2.1P
+ PS=10.42U PD=10.42U
* device instance $373 r0 *1 864.29,648.04 nfet
M$373 GND_DRV x3_lockout OUT GND_LOGIC nfet L=0.7U W=10U AS=2.1P AD=2.1P
+ PS=10.42U PD=10.42U
* device instance $374 r0 *1 865.41,648.04 nfet
M$374 OUT x3_lockout GND_DRV GND_LOGIC nfet L=0.7U W=10U AS=2.1P AD=2.1P
+ PS=10.42U PD=10.42U
* device instance $375 r0 *1 866.53,648.04 nfet
M$375 GND_DRV x3_lockout OUT GND_LOGIC nfet L=0.7U W=10U AS=2.1P AD=2.1P
+ PS=10.42U PD=10.42U
* device instance $376 r0 *1 867.65,648.04 nfet
M$376 OUT x3_lockout GND_DRV GND_LOGIC nfet L=0.7U W=10U AS=2.1P AD=2.1P
+ PS=10.42U PD=10.42U
* device instance $377 r0 *1 868.77,648.04 nfet
M$377 GND_DRV x3_lockout OUT GND_LOGIC nfet L=0.7U W=10U AS=2.1P AD=2.1P
+ PS=10.42U PD=10.42U
* device instance $378 r0 *1 869.89,648.04 nfet
M$378 OUT x3_lockout GND_DRV GND_LOGIC nfet L=0.7U W=10U AS=2.1P AD=2.1P
+ PS=10.42U PD=10.42U
* device instance $379 r0 *1 871.01,648.04 nfet
M$379 GND_DRV x3_lockout OUT GND_LOGIC nfet L=0.7U W=10U AS=2.1P AD=2.1P
+ PS=10.42U PD=10.42U
* device instance $380 r0 *1 872.13,648.04 nfet
M$380 OUT x3_lockout GND_DRV GND_LOGIC nfet L=0.7U W=10U AS=2.1P AD=2.1P
+ PS=10.42U PD=10.42U
* device instance $381 r0 *1 873.25,648.04 nfet
M$381 GND_DRV x3_lockout OUT GND_LOGIC nfet L=0.7U W=10U AS=2.1P AD=2.1P
+ PS=10.42U PD=10.42U
* device instance $382 r0 *1 874.37,648.04 nfet
M$382 OUT x3_lockout GND_DRV GND_LOGIC nfet L=0.7U W=10U AS=2.1P AD=2.1P
+ PS=10.42U PD=10.42U
* device instance $383 r0 *1 875.49,648.04 nfet
M$383 GND_DRV x3_lockout OUT GND_LOGIC nfet L=0.7U W=10U AS=2.1P AD=2.1P
+ PS=10.42U PD=10.42U
* device instance $384 r0 *1 876.61,648.04 nfet
M$384 OUT x3_lockout GND_DRV GND_LOGIC nfet L=0.7U W=10U AS=2.1P AD=2.1P
+ PS=10.42U PD=10.42U
* device instance $385 r0 *1 877.73,648.04 nfet
M$385 GND_DRV x3_lockout OUT GND_LOGIC nfet L=0.7U W=10U AS=2.1P AD=2.1P
+ PS=10.42U PD=10.42U
* device instance $386 r0 *1 878.85,648.04 nfet
M$386 OUT x3_lockout GND_DRV GND_LOGIC nfet L=0.7U W=10U AS=2.1P AD=2.1P
+ PS=10.42U PD=10.42U
* device instance $387 r0 *1 879.97,648.04 nfet
M$387 GND_DRV x3_lockout OUT GND_LOGIC nfet L=0.7U W=10U AS=2.1P AD=2.1P
+ PS=10.42U PD=10.42U
* device instance $388 r0 *1 881.09,648.04 nfet
M$388 OUT x3_lockout GND_DRV GND_LOGIC nfet L=0.7U W=10U AS=2.1P AD=2.1P
+ PS=10.42U PD=10.42U
* device instance $389 r0 *1 882.21,648.04 nfet
M$389 GND_DRV x3_lockout OUT GND_LOGIC nfet L=0.7U W=10U AS=2.1P AD=2.1P
+ PS=10.42U PD=10.42U
* device instance $390 r0 *1 883.33,648.04 nfet
M$390 OUT x3_lockout GND_DRV GND_LOGIC nfet L=0.7U W=10U AS=2.1P AD=2.1P
+ PS=10.42U PD=10.42U
* device instance $391 r0 *1 884.45,648.04 nfet
M$391 GND_DRV x3_lockout OUT GND_LOGIC nfet L=0.7U W=10U AS=2.1P AD=2.1P
+ PS=10.42U PD=10.42U
* device instance $392 r0 *1 885.57,648.04 nfet
M$392 OUT x3_lockout GND_DRV GND_LOGIC nfet L=0.7U W=10U AS=2.1P AD=2.1P
+ PS=10.42U PD=10.42U
* device instance $393 r0 *1 886.69,648.04 nfet
M$393 GND_DRV x3_lockout OUT GND_LOGIC nfet L=0.7U W=10U AS=2.1P AD=2.1P
+ PS=10.42U PD=10.42U
* device instance $394 r0 *1 887.81,648.04 nfet
M$394 OUT x3_lockout GND_DRV GND_LOGIC nfet L=0.7U W=10U AS=2.1P AD=2.1P
+ PS=10.42U PD=10.42U
* device instance $395 r0 *1 888.93,648.04 nfet
M$395 GND_DRV x3_lockout OUT GND_LOGIC nfet L=0.7U W=10U AS=2.1P AD=2.1P
+ PS=10.42U PD=10.42U
* device instance $396 r0 *1 890.05,648.04 nfet
M$396 OUT x3_lockout GND_DRV GND_LOGIC nfet L=0.7U W=10U AS=2.1P AD=2.1P
+ PS=10.42U PD=10.42U
* device instance $397 r0 *1 891.17,648.04 nfet
M$397 GND_DRV x3_lockout OUT GND_LOGIC nfet L=0.7U W=10U AS=2.1P AD=2.1P
+ PS=10.42U PD=10.42U
* device instance $398 r0 *1 892.29,648.04 nfet
M$398 OUT x3_lockout GND_DRV GND_LOGIC nfet L=0.7U W=10U AS=2.1P AD=2.1P
+ PS=10.42U PD=10.42U
* device instance $399 r0 *1 893.41,648.04 nfet
M$399 GND_DRV x3_lockout OUT GND_LOGIC nfet L=0.7U W=10U AS=2.1P AD=2.1P
+ PS=10.42U PD=10.42U
* device instance $400 r0 *1 894.53,648.04 nfet
M$400 OUT x3_lockout GND_DRV GND_LOGIC nfet L=0.7U W=10U AS=2.1P AD=2.1P
+ PS=10.42U PD=10.42U
* device instance $401 r0 *1 895.65,648.04 nfet
M$401 GND_DRV x3_lockout OUT GND_LOGIC nfet L=0.7U W=10U AS=2.1P AD=4.2P
+ PS=10.42U PD=20.84U
* device instance $402 r0 *1 672.77,648.04 nfet
M$402 OUT x3_lockout GND_DRV GND_LOGIC nfet L=0.7U W=10U AS=2.1P AD=2.1P
+ PS=10.42U PD=10.42U
* device instance $403 r0 *1 673.89,648.04 nfet
M$403 GND_DRV x3_lockout OUT GND_LOGIC nfet L=0.7U W=10U AS=2.1P AD=2.1P
+ PS=10.42U PD=10.42U
* device instance $404 r0 *1 675.01,648.04 nfet
M$404 OUT x3_lockout GND_DRV GND_LOGIC nfet L=0.7U W=10U AS=2.1P AD=2.1P
+ PS=10.42U PD=10.42U
* device instance $405 r0 *1 676.13,648.04 nfet
M$405 GND_DRV x3_lockout OUT GND_LOGIC nfet L=0.7U W=10U AS=2.1P AD=2.1P
+ PS=10.42U PD=10.42U
* device instance $406 r0 *1 677.25,648.04 nfet
M$406 OUT x3_lockout GND_DRV GND_LOGIC nfet L=0.7U W=10U AS=2.1P AD=2.1P
+ PS=10.42U PD=10.42U
* device instance $407 r0 *1 678.37,648.04 nfet
M$407 GND_DRV x3_lockout OUT GND_LOGIC nfet L=0.7U W=10U AS=2.1P AD=2.1P
+ PS=10.42U PD=10.42U
* device instance $408 r0 *1 679.49,648.04 nfet
M$408 OUT x3_lockout GND_DRV GND_LOGIC nfet L=0.7U W=10U AS=2.1P AD=2.1P
+ PS=10.42U PD=10.42U
* device instance $409 r0 *1 680.61,648.04 nfet
M$409 GND_DRV x3_lockout OUT GND_LOGIC nfet L=0.7U W=10U AS=2.1P AD=2.1P
+ PS=10.42U PD=10.42U
* device instance $410 r0 *1 681.73,648.04 nfet
M$410 OUT x3_lockout GND_DRV GND_LOGIC nfet L=0.7U W=10U AS=2.1P AD=2.1P
+ PS=10.42U PD=10.42U
* device instance $411 r0 *1 682.85,648.04 nfet
M$411 GND_DRV x3_lockout OUT GND_LOGIC nfet L=0.7U W=10U AS=2.1P AD=2.1P
+ PS=10.42U PD=10.42U
* device instance $412 r0 *1 683.97,648.04 nfet
M$412 OUT x3_lockout GND_DRV GND_LOGIC nfet L=0.7U W=10U AS=2.1P AD=2.1P
+ PS=10.42U PD=10.42U
* device instance $413 r0 *1 685.09,648.04 nfet
M$413 GND_DRV x3_lockout OUT GND_LOGIC nfet L=0.7U W=10U AS=2.1P AD=2.1P
+ PS=10.42U PD=10.42U
* device instance $414 r0 *1 686.21,648.04 nfet
M$414 OUT x3_lockout GND_DRV GND_LOGIC nfet L=0.7U W=10U AS=2.1P AD=2.1P
+ PS=10.42U PD=10.42U
* device instance $415 r0 *1 687.33,648.04 nfet
M$415 GND_DRV x3_lockout OUT GND_LOGIC nfet L=0.7U W=10U AS=2.1P AD=2.1P
+ PS=10.42U PD=10.42U
* device instance $416 r0 *1 688.45,648.04 nfet
M$416 OUT x3_lockout GND_DRV GND_LOGIC nfet L=0.7U W=10U AS=2.1P AD=2.1P
+ PS=10.42U PD=10.42U
* device instance $417 r0 *1 689.57,648.04 nfet
M$417 GND_DRV x3_lockout OUT GND_LOGIC nfet L=0.7U W=10U AS=2.1P AD=2.1P
+ PS=10.42U PD=10.42U
* device instance $418 r0 *1 690.69,648.04 nfet
M$418 OUT x3_lockout GND_DRV GND_LOGIC nfet L=0.7U W=10U AS=2.1P AD=2.1P
+ PS=10.42U PD=10.42U
* device instance $419 r0 *1 691.81,648.04 nfet
M$419 GND_DRV x3_lockout OUT GND_LOGIC nfet L=0.7U W=10U AS=2.1P AD=2.1P
+ PS=10.42U PD=10.42U
* device instance $420 r0 *1 692.93,648.04 nfet
M$420 OUT x3_lockout GND_DRV GND_LOGIC nfet L=0.7U W=10U AS=2.1P AD=2.1P
+ PS=10.42U PD=10.42U
* device instance $421 r0 *1 694.05,648.04 nfet
M$421 GND_DRV x3_lockout OUT GND_LOGIC nfet L=0.7U W=10U AS=2.1P AD=2.1P
+ PS=10.42U PD=10.42U
* device instance $422 r0 *1 695.17,648.04 nfet
M$422 OUT x3_lockout GND_DRV GND_LOGIC nfet L=0.7U W=10U AS=2.1P AD=2.1P
+ PS=10.42U PD=10.42U
* device instance $423 r0 *1 696.29,648.04 nfet
M$423 GND_DRV x3_lockout OUT GND_LOGIC nfet L=0.7U W=10U AS=2.1P AD=2.1P
+ PS=10.42U PD=10.42U
* device instance $424 r0 *1 697.41,648.04 nfet
M$424 OUT x3_lockout GND_DRV GND_LOGIC nfet L=0.7U W=10U AS=2.1P AD=2.1P
+ PS=10.42U PD=10.42U
* device instance $425 r0 *1 698.53,648.04 nfet
M$425 GND_DRV x3_lockout OUT GND_LOGIC nfet L=0.7U W=10U AS=2.1P AD=2.1P
+ PS=10.42U PD=10.42U
* device instance $426 r0 *1 699.65,648.04 nfet
M$426 OUT x3_lockout GND_DRV GND_LOGIC nfet L=0.7U W=10U AS=2.1P AD=2.1P
+ PS=10.42U PD=10.42U
* device instance $427 r0 *1 700.77,648.04 nfet
M$427 GND_DRV x3_lockout OUT GND_LOGIC nfet L=0.7U W=10U AS=2.1P AD=2.1P
+ PS=10.42U PD=10.42U
* device instance $428 r0 *1 701.89,648.04 nfet
M$428 OUT x3_lockout GND_DRV GND_LOGIC nfet L=0.7U W=10U AS=2.1P AD=2.1P
+ PS=10.42U PD=10.42U
* device instance $429 r0 *1 703.01,648.04 nfet
M$429 GND_DRV x3_lockout OUT GND_LOGIC nfet L=0.7U W=10U AS=2.1P AD=2.1P
+ PS=10.42U PD=10.42U
* device instance $430 r0 *1 704.13,648.04 nfet
M$430 OUT x3_lockout GND_DRV GND_LOGIC nfet L=0.7U W=10U AS=2.1P AD=2.1P
+ PS=10.42U PD=10.42U
* device instance $431 r0 *1 705.25,648.04 nfet
M$431 GND_DRV x3_lockout OUT GND_LOGIC nfet L=0.7U W=10U AS=2.1P AD=2.1P
+ PS=10.42U PD=10.42U
* device instance $432 r0 *1 706.37,648.04 nfet
M$432 OUT x3_lockout GND_DRV GND_LOGIC nfet L=0.7U W=10U AS=2.1P AD=2.1P
+ PS=10.42U PD=10.42U
* device instance $433 r0 *1 707.49,648.04 nfet
M$433 GND_DRV x3_lockout OUT GND_LOGIC nfet L=0.7U W=10U AS=2.1P AD=2.1P
+ PS=10.42U PD=10.42U
* device instance $434 r0 *1 708.61,648.04 nfet
M$434 OUT x3_lockout GND_DRV GND_LOGIC nfet L=0.7U W=10U AS=2.1P AD=2.1P
+ PS=10.42U PD=10.42U
* device instance $435 r0 *1 709.73,648.04 nfet
M$435 GND_DRV x3_lockout OUT GND_LOGIC nfet L=0.7U W=10U AS=2.1P AD=2.1P
+ PS=10.42U PD=10.42U
* device instance $436 r0 *1 710.85,648.04 nfet
M$436 OUT x3_lockout GND_DRV GND_LOGIC nfet L=0.7U W=10U AS=2.1P AD=2.1P
+ PS=10.42U PD=10.42U
* device instance $437 r0 *1 711.97,648.04 nfet
M$437 GND_DRV x3_lockout OUT GND_LOGIC nfet L=0.7U W=10U AS=2.1P AD=2.1P
+ PS=10.42U PD=10.42U
* device instance $438 r0 *1 713.09,648.04 nfet
M$438 OUT x3_lockout GND_DRV GND_LOGIC nfet L=0.7U W=10U AS=2.1P AD=2.1P
+ PS=10.42U PD=10.42U
* device instance $439 r0 *1 714.21,648.04 nfet
M$439 GND_DRV x3_lockout OUT GND_LOGIC nfet L=0.7U W=10U AS=2.1P AD=2.1P
+ PS=10.42U PD=10.42U
* device instance $440 r0 *1 715.33,648.04 nfet
M$440 OUT x3_lockout GND_DRV GND_LOGIC nfet L=0.7U W=10U AS=2.1P AD=2.1P
+ PS=10.42U PD=10.42U
* device instance $441 r0 *1 716.45,648.04 nfet
M$441 GND_DRV x3_lockout OUT GND_LOGIC nfet L=0.7U W=10U AS=2.1P AD=2.1P
+ PS=10.42U PD=10.42U
* device instance $442 r0 *1 717.57,648.04 nfet
M$442 OUT x3_lockout GND_DRV GND_LOGIC nfet L=0.7U W=10U AS=2.1P AD=2.1P
+ PS=10.42U PD=10.42U
* device instance $443 r0 *1 718.69,648.04 nfet
M$443 GND_DRV x3_lockout OUT GND_LOGIC nfet L=0.7U W=10U AS=2.1P AD=2.1P
+ PS=10.42U PD=10.42U
* device instance $444 r0 *1 719.81,648.04 nfet
M$444 OUT x3_lockout GND_DRV GND_LOGIC nfet L=0.7U W=10U AS=2.1P AD=2.1P
+ PS=10.42U PD=10.42U
* device instance $445 r0 *1 720.93,648.04 nfet
M$445 GND_DRV x3_lockout OUT GND_LOGIC nfet L=0.7U W=10U AS=2.1P AD=2.1P
+ PS=10.42U PD=10.42U
* device instance $446 r0 *1 722.05,648.04 nfet
M$446 OUT x3_lockout GND_DRV GND_LOGIC nfet L=0.7U W=10U AS=2.1P AD=2.1P
+ PS=10.42U PD=10.42U
* device instance $447 r0 *1 723.17,648.04 nfet
M$447 GND_DRV x3_lockout OUT GND_LOGIC nfet L=0.7U W=10U AS=2.1P AD=2.1P
+ PS=10.42U PD=10.42U
* device instance $448 r0 *1 724.29,648.04 nfet
M$448 OUT x3_lockout GND_DRV GND_LOGIC nfet L=0.7U W=10U AS=2.1P AD=2.1P
+ PS=10.42U PD=10.42U
* device instance $449 r0 *1 725.41,648.04 nfet
M$449 GND_DRV x3_lockout OUT GND_LOGIC nfet L=0.7U W=10U AS=2.1P AD=2.1P
+ PS=10.42U PD=10.42U
* device instance $450 r0 *1 726.53,648.04 nfet
M$450 OUT x3_lockout GND_DRV GND_LOGIC nfet L=0.7U W=10U AS=2.1P AD=2.1P
+ PS=10.42U PD=10.42U
* device instance $451 r0 *1 727.65,648.04 nfet
M$451 GND_DRV x3_lockout OUT GND_LOGIC nfet L=0.7U W=10U AS=2.1P AD=2.1P
+ PS=10.42U PD=10.42U
* device instance $452 r0 *1 728.77,648.04 nfet
M$452 OUT x3_lockout GND_DRV GND_LOGIC nfet L=0.7U W=10U AS=2.1P AD=2.1P
+ PS=10.42U PD=10.42U
* device instance $453 r0 *1 729.89,648.04 nfet
M$453 GND_DRV x3_lockout OUT GND_LOGIC nfet L=0.7U W=10U AS=2.1P AD=2.1P
+ PS=10.42U PD=10.42U
* device instance $454 r0 *1 731.01,648.04 nfet
M$454 OUT x3_lockout GND_DRV GND_LOGIC nfet L=0.7U W=10U AS=2.1P AD=2.1P
+ PS=10.42U PD=10.42U
* device instance $455 r0 *1 732.13,648.04 nfet
M$455 GND_DRV x3_lockout OUT GND_LOGIC nfet L=0.7U W=10U AS=2.1P AD=2.1P
+ PS=10.42U PD=10.42U
* device instance $456 r0 *1 733.25,648.04 nfet
M$456 OUT x3_lockout GND_DRV GND_LOGIC nfet L=0.7U W=10U AS=2.1P AD=2.1P
+ PS=10.42U PD=10.42U
* device instance $457 r0 *1 734.37,648.04 nfet
M$457 GND_DRV x3_lockout OUT GND_LOGIC nfet L=0.7U W=10U AS=2.1P AD=2.1P
+ PS=10.42U PD=10.42U
* device instance $458 r0 *1 735.49,648.04 nfet
M$458 OUT x3_lockout GND_DRV GND_LOGIC nfet L=0.7U W=10U AS=2.1P AD=2.1P
+ PS=10.42U PD=10.42U
* device instance $459 r0 *1 736.61,648.04 nfet
M$459 GND_DRV x3_lockout OUT GND_LOGIC nfet L=0.7U W=10U AS=2.1P AD=2.1P
+ PS=10.42U PD=10.42U
* device instance $460 r0 *1 737.73,648.04 nfet
M$460 OUT x3_lockout GND_DRV GND_LOGIC nfet L=0.7U W=10U AS=2.1P AD=2.1P
+ PS=10.42U PD=10.42U
* device instance $461 r0 *1 738.85,648.04 nfet
M$461 GND_DRV x3_lockout OUT GND_LOGIC nfet L=0.7U W=10U AS=2.1P AD=2.1P
+ PS=10.42U PD=10.42U
* device instance $462 r0 *1 739.97,648.04 nfet
M$462 OUT x3_lockout GND_DRV GND_LOGIC nfet L=0.7U W=10U AS=2.1P AD=2.1P
+ PS=10.42U PD=10.42U
* device instance $463 r0 *1 741.09,648.04 nfet
M$463 GND_DRV x3_lockout OUT GND_LOGIC nfet L=0.7U W=10U AS=2.1P AD=2.1P
+ PS=10.42U PD=10.42U
* device instance $464 r0 *1 742.21,648.04 nfet
M$464 OUT x3_lockout GND_DRV GND_LOGIC nfet L=0.7U W=10U AS=2.1P AD=2.1P
+ PS=10.42U PD=10.42U
* device instance $465 r0 *1 743.33,648.04 nfet
M$465 GND_DRV x3_lockout OUT GND_LOGIC nfet L=0.7U W=10U AS=2.1P AD=2.1P
+ PS=10.42U PD=10.42U
* device instance $466 r0 *1 744.45,648.04 nfet
M$466 OUT x3_lockout GND_DRV GND_LOGIC nfet L=0.7U W=10U AS=2.1P AD=2.1P
+ PS=10.42U PD=10.42U
* device instance $467 r0 *1 745.57,648.04 nfet
M$467 GND_DRV x3_lockout OUT GND_LOGIC nfet L=0.7U W=10U AS=2.1P AD=2.1P
+ PS=10.42U PD=10.42U
* device instance $468 r0 *1 746.69,648.04 nfet
M$468 OUT x3_lockout GND_DRV GND_LOGIC nfet L=0.7U W=10U AS=2.1P AD=2.1P
+ PS=10.42U PD=10.42U
* device instance $469 r0 *1 747.81,648.04 nfet
M$469 GND_DRV x3_lockout OUT GND_LOGIC nfet L=0.7U W=10U AS=2.1P AD=2.1P
+ PS=10.42U PD=10.42U
* device instance $470 r0 *1 748.93,648.04 nfet
M$470 OUT x3_lockout GND_DRV GND_LOGIC nfet L=0.7U W=10U AS=2.1P AD=2.1P
+ PS=10.42U PD=10.42U
* device instance $471 r0 *1 750.05,648.04 nfet
M$471 GND_DRV x3_lockout OUT GND_LOGIC nfet L=0.7U W=10U AS=2.1P AD=2.1P
+ PS=10.42U PD=10.42U
* device instance $472 r0 *1 751.17,648.04 nfet
M$472 OUT x3_lockout GND_DRV GND_LOGIC nfet L=0.7U W=10U AS=2.1P AD=2.1P
+ PS=10.42U PD=10.42U
* device instance $473 r0 *1 752.29,648.04 nfet
M$473 GND_DRV x3_lockout OUT GND_LOGIC nfet L=0.7U W=10U AS=2.1P AD=2.1P
+ PS=10.42U PD=10.42U
* device instance $474 r0 *1 753.41,648.04 nfet
M$474 OUT x3_lockout GND_DRV GND_LOGIC nfet L=0.7U W=10U AS=2.1P AD=2.1P
+ PS=10.42U PD=10.42U
* device instance $475 r0 *1 754.53,648.04 nfet
M$475 GND_DRV x3_lockout OUT GND_LOGIC nfet L=0.7U W=10U AS=2.1P AD=2.1P
+ PS=10.42U PD=10.42U
* device instance $476 r0 *1 755.65,648.04 nfet
M$476 OUT x3_lockout GND_DRV GND_LOGIC nfet L=0.7U W=10U AS=2.1P AD=2.1P
+ PS=10.42U PD=10.42U
* device instance $477 r0 *1 756.77,648.04 nfet
M$477 GND_DRV x3_lockout OUT GND_LOGIC nfet L=0.7U W=10U AS=2.1P AD=2.1P
+ PS=10.42U PD=10.42U
* device instance $478 r0 *1 757.89,648.04 nfet
M$478 OUT x3_lockout GND_DRV GND_LOGIC nfet L=0.7U W=10U AS=2.1P AD=2.1P
+ PS=10.42U PD=10.42U
* device instance $479 r0 *1 759.01,648.04 nfet
M$479 GND_DRV x3_lockout OUT GND_LOGIC nfet L=0.7U W=10U AS=2.1P AD=2.1P
+ PS=10.42U PD=10.42U
* device instance $480 r0 *1 760.13,648.04 nfet
M$480 OUT x3_lockout GND_DRV GND_LOGIC nfet L=0.7U W=10U AS=2.1P AD=2.1P
+ PS=10.42U PD=10.42U
* device instance $481 r0 *1 761.25,648.04 nfet
M$481 GND_DRV x3_lockout OUT GND_LOGIC nfet L=0.7U W=10U AS=2.1P AD=2.1P
+ PS=10.42U PD=10.42U
* device instance $482 r0 *1 762.37,648.04 nfet
M$482 OUT x3_lockout GND_DRV GND_LOGIC nfet L=0.7U W=10U AS=2.1P AD=2.1P
+ PS=10.42U PD=10.42U
* device instance $483 r0 *1 763.49,648.04 nfet
M$483 GND_DRV x3_lockout OUT GND_LOGIC nfet L=0.7U W=10U AS=2.1P AD=2.1P
+ PS=10.42U PD=10.42U
* device instance $484 r0 *1 764.61,648.04 nfet
M$484 OUT x3_lockout GND_DRV GND_LOGIC nfet L=0.7U W=10U AS=2.1P AD=2.1P
+ PS=10.42U PD=10.42U
* device instance $485 r0 *1 765.73,648.04 nfet
M$485 GND_DRV x3_lockout OUT GND_LOGIC nfet L=0.7U W=10U AS=2.1P AD=2.1P
+ PS=10.42U PD=10.42U
* device instance $486 r0 *1 766.85,648.04 nfet
M$486 OUT x3_lockout GND_DRV GND_LOGIC nfet L=0.7U W=10U AS=2.1P AD=2.1P
+ PS=10.42U PD=10.42U
* device instance $487 r0 *1 767.97,648.04 nfet
M$487 GND_DRV x3_lockout OUT GND_LOGIC nfet L=0.7U W=10U AS=2.1P AD=2.1P
+ PS=10.42U PD=10.42U
* device instance $488 r0 *1 769.09,648.04 nfet
M$488 OUT x3_lockout GND_DRV GND_LOGIC nfet L=0.7U W=10U AS=2.1P AD=2.1P
+ PS=10.42U PD=10.42U
* device instance $489 r0 *1 770.21,648.04 nfet
M$489 GND_DRV x3_lockout OUT GND_LOGIC nfet L=0.7U W=10U AS=2.1P AD=2.1P
+ PS=10.42U PD=10.42U
* device instance $490 r0 *1 771.33,648.04 nfet
M$490 OUT x3_lockout GND_DRV GND_LOGIC nfet L=0.7U W=10U AS=2.1P AD=2.1P
+ PS=10.42U PD=10.42U
* device instance $491 r0 *1 772.45,648.04 nfet
M$491 GND_DRV x3_lockout OUT GND_LOGIC nfet L=0.7U W=10U AS=2.1P AD=2.1P
+ PS=10.42U PD=10.42U
* device instance $492 r0 *1 773.57,648.04 nfet
M$492 OUT x3_lockout GND_DRV GND_LOGIC nfet L=0.7U W=10U AS=2.1P AD=2.1P
+ PS=10.42U PD=10.42U
* device instance $493 r0 *1 774.69,648.04 nfet
M$493 GND_DRV x3_lockout OUT GND_LOGIC nfet L=0.7U W=10U AS=2.1P AD=2.1P
+ PS=10.42U PD=10.42U
* device instance $494 r0 *1 775.81,648.04 nfet
M$494 OUT x3_lockout GND_DRV GND_LOGIC nfet L=0.7U W=10U AS=2.1P AD=2.1P
+ PS=10.42U PD=10.42U
* device instance $495 r0 *1 776.93,648.04 nfet
M$495 GND_DRV x3_lockout OUT GND_LOGIC nfet L=0.7U W=10U AS=2.1P AD=2.1P
+ PS=10.42U PD=10.42U
* device instance $496 r0 *1 778.05,648.04 nfet
M$496 OUT x3_lockout GND_DRV GND_LOGIC nfet L=0.7U W=10U AS=2.1P AD=2.1P
+ PS=10.42U PD=10.42U
* device instance $497 r0 *1 779.17,648.04 nfet
M$497 GND_DRV x3_lockout OUT GND_LOGIC nfet L=0.7U W=10U AS=2.1P AD=2.1P
+ PS=10.42U PD=10.42U
* device instance $498 r0 *1 780.29,648.04 nfet
M$498 OUT x3_lockout GND_DRV GND_LOGIC nfet L=0.7U W=10U AS=2.1P AD=2.1P
+ PS=10.42U PD=10.42U
* device instance $499 r0 *1 781.41,648.04 nfet
M$499 GND_DRV x3_lockout OUT GND_LOGIC nfet L=0.7U W=10U AS=2.1P AD=2.1P
+ PS=10.42U PD=10.42U
* device instance $500 r0 *1 782.53,648.04 nfet
M$500 OUT x3_lockout GND_DRV GND_LOGIC nfet L=0.7U W=10U AS=2.1P AD=2.1P
+ PS=10.42U PD=10.42U
* device instance $501 r0 *1 783.65,648.04 nfet
M$501 GND_DRV x3_lockout OUT GND_LOGIC nfet L=0.7U W=10U AS=2.1P AD=2.1P
+ PS=10.42U PD=10.42U
* device instance $502 r0 *1 560.77,648.04 nfet
M$502 OUT x3_lockout GND_DRV GND_LOGIC nfet L=0.7U W=10U AS=2.1P AD=2.1P
+ PS=10.42U PD=10.42U
* device instance $503 r0 *1 561.89,648.04 nfet
M$503 GND_DRV x3_lockout OUT GND_LOGIC nfet L=0.7U W=10U AS=2.1P AD=2.1P
+ PS=10.42U PD=10.42U
* device instance $504 r0 *1 563.01,648.04 nfet
M$504 OUT x3_lockout GND_DRV GND_LOGIC nfet L=0.7U W=10U AS=2.1P AD=2.1P
+ PS=10.42U PD=10.42U
* device instance $505 r0 *1 564.13,648.04 nfet
M$505 GND_DRV x3_lockout OUT GND_LOGIC nfet L=0.7U W=10U AS=2.1P AD=2.1P
+ PS=10.42U PD=10.42U
* device instance $506 r0 *1 565.25,648.04 nfet
M$506 OUT x3_lockout GND_DRV GND_LOGIC nfet L=0.7U W=10U AS=2.1P AD=2.1P
+ PS=10.42U PD=10.42U
* device instance $507 r0 *1 566.37,648.04 nfet
M$507 GND_DRV x3_lockout OUT GND_LOGIC nfet L=0.7U W=10U AS=2.1P AD=2.1P
+ PS=10.42U PD=10.42U
* device instance $508 r0 *1 567.49,648.04 nfet
M$508 OUT x3_lockout GND_DRV GND_LOGIC nfet L=0.7U W=10U AS=2.1P AD=2.1P
+ PS=10.42U PD=10.42U
* device instance $509 r0 *1 568.61,648.04 nfet
M$509 GND_DRV x3_lockout OUT GND_LOGIC nfet L=0.7U W=10U AS=2.1P AD=2.1P
+ PS=10.42U PD=10.42U
* device instance $510 r0 *1 569.73,648.04 nfet
M$510 OUT x3_lockout GND_DRV GND_LOGIC nfet L=0.7U W=10U AS=2.1P AD=2.1P
+ PS=10.42U PD=10.42U
* device instance $511 r0 *1 570.85,648.04 nfet
M$511 GND_DRV x3_lockout OUT GND_LOGIC nfet L=0.7U W=10U AS=2.1P AD=2.1P
+ PS=10.42U PD=10.42U
* device instance $512 r0 *1 571.97,648.04 nfet
M$512 OUT x3_lockout GND_DRV GND_LOGIC nfet L=0.7U W=10U AS=2.1P AD=2.1P
+ PS=10.42U PD=10.42U
* device instance $513 r0 *1 573.09,648.04 nfet
M$513 GND_DRV x3_lockout OUT GND_LOGIC nfet L=0.7U W=10U AS=2.1P AD=2.1P
+ PS=10.42U PD=10.42U
* device instance $514 r0 *1 574.21,648.04 nfet
M$514 OUT x3_lockout GND_DRV GND_LOGIC nfet L=0.7U W=10U AS=2.1P AD=2.1P
+ PS=10.42U PD=10.42U
* device instance $515 r0 *1 575.33,648.04 nfet
M$515 GND_DRV x3_lockout OUT GND_LOGIC nfet L=0.7U W=10U AS=2.1P AD=2.1P
+ PS=10.42U PD=10.42U
* device instance $516 r0 *1 576.45,648.04 nfet
M$516 OUT x3_lockout GND_DRV GND_LOGIC nfet L=0.7U W=10U AS=2.1P AD=2.1P
+ PS=10.42U PD=10.42U
* device instance $517 r0 *1 577.57,648.04 nfet
M$517 GND_DRV x3_lockout OUT GND_LOGIC nfet L=0.7U W=10U AS=2.1P AD=2.1P
+ PS=10.42U PD=10.42U
* device instance $518 r0 *1 578.69,648.04 nfet
M$518 OUT x3_lockout GND_DRV GND_LOGIC nfet L=0.7U W=10U AS=2.1P AD=2.1P
+ PS=10.42U PD=10.42U
* device instance $519 r0 *1 579.81,648.04 nfet
M$519 GND_DRV x3_lockout OUT GND_LOGIC nfet L=0.7U W=10U AS=2.1P AD=2.1P
+ PS=10.42U PD=10.42U
* device instance $520 r0 *1 580.93,648.04 nfet
M$520 OUT x3_lockout GND_DRV GND_LOGIC nfet L=0.7U W=10U AS=2.1P AD=2.1P
+ PS=10.42U PD=10.42U
* device instance $521 r0 *1 582.05,648.04 nfet
M$521 GND_DRV x3_lockout OUT GND_LOGIC nfet L=0.7U W=10U AS=2.1P AD=2.1P
+ PS=10.42U PD=10.42U
* device instance $522 r0 *1 583.17,648.04 nfet
M$522 OUT x3_lockout GND_DRV GND_LOGIC nfet L=0.7U W=10U AS=2.1P AD=2.1P
+ PS=10.42U PD=10.42U
* device instance $523 r0 *1 584.29,648.04 nfet
M$523 GND_DRV x3_lockout OUT GND_LOGIC nfet L=0.7U W=10U AS=2.1P AD=2.1P
+ PS=10.42U PD=10.42U
* device instance $524 r0 *1 585.41,648.04 nfet
M$524 OUT x3_lockout GND_DRV GND_LOGIC nfet L=0.7U W=10U AS=2.1P AD=2.1P
+ PS=10.42U PD=10.42U
* device instance $525 r0 *1 586.53,648.04 nfet
M$525 GND_DRV x3_lockout OUT GND_LOGIC nfet L=0.7U W=10U AS=2.1P AD=2.1P
+ PS=10.42U PD=10.42U
* device instance $526 r0 *1 587.65,648.04 nfet
M$526 OUT x3_lockout GND_DRV GND_LOGIC nfet L=0.7U W=10U AS=2.1P AD=2.1P
+ PS=10.42U PD=10.42U
* device instance $527 r0 *1 588.77,648.04 nfet
M$527 GND_DRV x3_lockout OUT GND_LOGIC nfet L=0.7U W=10U AS=2.1P AD=2.1P
+ PS=10.42U PD=10.42U
* device instance $528 r0 *1 589.89,648.04 nfet
M$528 OUT x3_lockout GND_DRV GND_LOGIC nfet L=0.7U W=10U AS=2.1P AD=2.1P
+ PS=10.42U PD=10.42U
* device instance $529 r0 *1 591.01,648.04 nfet
M$529 GND_DRV x3_lockout OUT GND_LOGIC nfet L=0.7U W=10U AS=2.1P AD=2.1P
+ PS=10.42U PD=10.42U
* device instance $530 r0 *1 592.13,648.04 nfet
M$530 OUT x3_lockout GND_DRV GND_LOGIC nfet L=0.7U W=10U AS=2.1P AD=2.1P
+ PS=10.42U PD=10.42U
* device instance $531 r0 *1 593.25,648.04 nfet
M$531 GND_DRV x3_lockout OUT GND_LOGIC nfet L=0.7U W=10U AS=2.1P AD=2.1P
+ PS=10.42U PD=10.42U
* device instance $532 r0 *1 594.37,648.04 nfet
M$532 OUT x3_lockout GND_DRV GND_LOGIC nfet L=0.7U W=10U AS=2.1P AD=2.1P
+ PS=10.42U PD=10.42U
* device instance $533 r0 *1 595.49,648.04 nfet
M$533 GND_DRV x3_lockout OUT GND_LOGIC nfet L=0.7U W=10U AS=2.1P AD=2.1P
+ PS=10.42U PD=10.42U
* device instance $534 r0 *1 596.61,648.04 nfet
M$534 OUT x3_lockout GND_DRV GND_LOGIC nfet L=0.7U W=10U AS=2.1P AD=2.1P
+ PS=10.42U PD=10.42U
* device instance $535 r0 *1 597.73,648.04 nfet
M$535 GND_DRV x3_lockout OUT GND_LOGIC nfet L=0.7U W=10U AS=2.1P AD=2.1P
+ PS=10.42U PD=10.42U
* device instance $536 r0 *1 598.85,648.04 nfet
M$536 OUT x3_lockout GND_DRV GND_LOGIC nfet L=0.7U W=10U AS=2.1P AD=2.1P
+ PS=10.42U PD=10.42U
* device instance $537 r0 *1 599.97,648.04 nfet
M$537 GND_DRV x3_lockout OUT GND_LOGIC nfet L=0.7U W=10U AS=2.1P AD=2.1P
+ PS=10.42U PD=10.42U
* device instance $538 r0 *1 601.09,648.04 nfet
M$538 OUT x3_lockout GND_DRV GND_LOGIC nfet L=0.7U W=10U AS=2.1P AD=2.1P
+ PS=10.42U PD=10.42U
* device instance $539 r0 *1 602.21,648.04 nfet
M$539 GND_DRV x3_lockout OUT GND_LOGIC nfet L=0.7U W=10U AS=2.1P AD=2.1P
+ PS=10.42U PD=10.42U
* device instance $540 r0 *1 603.33,648.04 nfet
M$540 OUT x3_lockout GND_DRV GND_LOGIC nfet L=0.7U W=10U AS=2.1P AD=2.1P
+ PS=10.42U PD=10.42U
* device instance $541 r0 *1 604.45,648.04 nfet
M$541 GND_DRV x3_lockout OUT GND_LOGIC nfet L=0.7U W=10U AS=2.1P AD=2.1P
+ PS=10.42U PD=10.42U
* device instance $542 r0 *1 605.57,648.04 nfet
M$542 OUT x3_lockout GND_DRV GND_LOGIC nfet L=0.7U W=10U AS=2.1P AD=2.1P
+ PS=10.42U PD=10.42U
* device instance $543 r0 *1 606.69,648.04 nfet
M$543 GND_DRV x3_lockout OUT GND_LOGIC nfet L=0.7U W=10U AS=2.1P AD=2.1P
+ PS=10.42U PD=10.42U
* device instance $544 r0 *1 607.81,648.04 nfet
M$544 OUT x3_lockout GND_DRV GND_LOGIC nfet L=0.7U W=10U AS=2.1P AD=2.1P
+ PS=10.42U PD=10.42U
* device instance $545 r0 *1 608.93,648.04 nfet
M$545 GND_DRV x3_lockout OUT GND_LOGIC nfet L=0.7U W=10U AS=2.1P AD=2.1P
+ PS=10.42U PD=10.42U
* device instance $546 r0 *1 610.05,648.04 nfet
M$546 OUT x3_lockout GND_DRV GND_LOGIC nfet L=0.7U W=10U AS=2.1P AD=2.1P
+ PS=10.42U PD=10.42U
* device instance $547 r0 *1 611.17,648.04 nfet
M$547 GND_DRV x3_lockout OUT GND_LOGIC nfet L=0.7U W=10U AS=2.1P AD=2.1P
+ PS=10.42U PD=10.42U
* device instance $548 r0 *1 612.29,648.04 nfet
M$548 OUT x3_lockout GND_DRV GND_LOGIC nfet L=0.7U W=10U AS=2.1P AD=2.1P
+ PS=10.42U PD=10.42U
* device instance $549 r0 *1 613.41,648.04 nfet
M$549 GND_DRV x3_lockout OUT GND_LOGIC nfet L=0.7U W=10U AS=2.1P AD=2.1P
+ PS=10.42U PD=10.42U
* device instance $550 r0 *1 614.53,648.04 nfet
M$550 OUT x3_lockout GND_DRV GND_LOGIC nfet L=0.7U W=10U AS=2.1P AD=2.1P
+ PS=10.42U PD=10.42U
* device instance $551 r0 *1 615.65,648.04 nfet
M$551 GND_DRV x3_lockout OUT GND_LOGIC nfet L=0.7U W=10U AS=2.1P AD=2.1P
+ PS=10.42U PD=10.42U
* device instance $552 r0 *1 616.77,648.04 nfet
M$552 OUT x3_lockout GND_DRV GND_LOGIC nfet L=0.7U W=10U AS=2.1P AD=2.1P
+ PS=10.42U PD=10.42U
* device instance $553 r0 *1 617.89,648.04 nfet
M$553 GND_DRV x3_lockout OUT GND_LOGIC nfet L=0.7U W=10U AS=2.1P AD=2.1P
+ PS=10.42U PD=10.42U
* device instance $554 r0 *1 619.01,648.04 nfet
M$554 OUT x3_lockout GND_DRV GND_LOGIC nfet L=0.7U W=10U AS=2.1P AD=2.1P
+ PS=10.42U PD=10.42U
* device instance $555 r0 *1 620.13,648.04 nfet
M$555 GND_DRV x3_lockout OUT GND_LOGIC nfet L=0.7U W=10U AS=2.1P AD=2.1P
+ PS=10.42U PD=10.42U
* device instance $556 r0 *1 621.25,648.04 nfet
M$556 OUT x3_lockout GND_DRV GND_LOGIC nfet L=0.7U W=10U AS=2.1P AD=2.1P
+ PS=10.42U PD=10.42U
* device instance $557 r0 *1 622.37,648.04 nfet
M$557 GND_DRV x3_lockout OUT GND_LOGIC nfet L=0.7U W=10U AS=2.1P AD=2.1P
+ PS=10.42U PD=10.42U
* device instance $558 r0 *1 623.49,648.04 nfet
M$558 OUT x3_lockout GND_DRV GND_LOGIC nfet L=0.7U W=10U AS=2.1P AD=2.1P
+ PS=10.42U PD=10.42U
* device instance $559 r0 *1 624.61,648.04 nfet
M$559 GND_DRV x3_lockout OUT GND_LOGIC nfet L=0.7U W=10U AS=2.1P AD=2.1P
+ PS=10.42U PD=10.42U
* device instance $560 r0 *1 625.73,648.04 nfet
M$560 OUT x3_lockout GND_DRV GND_LOGIC nfet L=0.7U W=10U AS=2.1P AD=2.1P
+ PS=10.42U PD=10.42U
* device instance $561 r0 *1 626.85,648.04 nfet
M$561 GND_DRV x3_lockout OUT GND_LOGIC nfet L=0.7U W=10U AS=2.1P AD=2.1P
+ PS=10.42U PD=10.42U
* device instance $562 r0 *1 627.97,648.04 nfet
M$562 OUT x3_lockout GND_DRV GND_LOGIC nfet L=0.7U W=10U AS=2.1P AD=2.1P
+ PS=10.42U PD=10.42U
* device instance $563 r0 *1 629.09,648.04 nfet
M$563 GND_DRV x3_lockout OUT GND_LOGIC nfet L=0.7U W=10U AS=2.1P AD=2.1P
+ PS=10.42U PD=10.42U
* device instance $564 r0 *1 630.21,648.04 nfet
M$564 OUT x3_lockout GND_DRV GND_LOGIC nfet L=0.7U W=10U AS=2.1P AD=2.1P
+ PS=10.42U PD=10.42U
* device instance $565 r0 *1 631.33,648.04 nfet
M$565 GND_DRV x3_lockout OUT GND_LOGIC nfet L=0.7U W=10U AS=2.1P AD=2.1P
+ PS=10.42U PD=10.42U
* device instance $566 r0 *1 632.45,648.04 nfet
M$566 OUT x3_lockout GND_DRV GND_LOGIC nfet L=0.7U W=10U AS=2.1P AD=2.1P
+ PS=10.42U PD=10.42U
* device instance $567 r0 *1 633.57,648.04 nfet
M$567 GND_DRV x3_lockout OUT GND_LOGIC nfet L=0.7U W=10U AS=2.1P AD=2.1P
+ PS=10.42U PD=10.42U
* device instance $568 r0 *1 634.69,648.04 nfet
M$568 OUT x3_lockout GND_DRV GND_LOGIC nfet L=0.7U W=10U AS=2.1P AD=2.1P
+ PS=10.42U PD=10.42U
* device instance $569 r0 *1 635.81,648.04 nfet
M$569 GND_DRV x3_lockout OUT GND_LOGIC nfet L=0.7U W=10U AS=2.1P AD=2.1P
+ PS=10.42U PD=10.42U
* device instance $570 r0 *1 636.93,648.04 nfet
M$570 OUT x3_lockout GND_DRV GND_LOGIC nfet L=0.7U W=10U AS=2.1P AD=2.1P
+ PS=10.42U PD=10.42U
* device instance $571 r0 *1 638.05,648.04 nfet
M$571 GND_DRV x3_lockout OUT GND_LOGIC nfet L=0.7U W=10U AS=2.1P AD=2.1P
+ PS=10.42U PD=10.42U
* device instance $572 r0 *1 639.17,648.04 nfet
M$572 OUT x3_lockout GND_DRV GND_LOGIC nfet L=0.7U W=10U AS=2.1P AD=2.1P
+ PS=10.42U PD=10.42U
* device instance $573 r0 *1 640.29,648.04 nfet
M$573 GND_DRV x3_lockout OUT GND_LOGIC nfet L=0.7U W=10U AS=2.1P AD=2.1P
+ PS=10.42U PD=10.42U
* device instance $574 r0 *1 641.41,648.04 nfet
M$574 OUT x3_lockout GND_DRV GND_LOGIC nfet L=0.7U W=10U AS=2.1P AD=2.1P
+ PS=10.42U PD=10.42U
* device instance $575 r0 *1 642.53,648.04 nfet
M$575 GND_DRV x3_lockout OUT GND_LOGIC nfet L=0.7U W=10U AS=2.1P AD=2.1P
+ PS=10.42U PD=10.42U
* device instance $576 r0 *1 643.65,648.04 nfet
M$576 OUT x3_lockout GND_DRV GND_LOGIC nfet L=0.7U W=10U AS=2.1P AD=2.1P
+ PS=10.42U PD=10.42U
* device instance $577 r0 *1 644.77,648.04 nfet
M$577 GND_DRV x3_lockout OUT GND_LOGIC nfet L=0.7U W=10U AS=2.1P AD=2.1P
+ PS=10.42U PD=10.42U
* device instance $578 r0 *1 645.89,648.04 nfet
M$578 OUT x3_lockout GND_DRV GND_LOGIC nfet L=0.7U W=10U AS=2.1P AD=2.1P
+ PS=10.42U PD=10.42U
* device instance $579 r0 *1 647.01,648.04 nfet
M$579 GND_DRV x3_lockout OUT GND_LOGIC nfet L=0.7U W=10U AS=2.1P AD=2.1P
+ PS=10.42U PD=10.42U
* device instance $580 r0 *1 648.13,648.04 nfet
M$580 OUT x3_lockout GND_DRV GND_LOGIC nfet L=0.7U W=10U AS=2.1P AD=2.1P
+ PS=10.42U PD=10.42U
* device instance $581 r0 *1 649.25,648.04 nfet
M$581 GND_DRV x3_lockout OUT GND_LOGIC nfet L=0.7U W=10U AS=2.1P AD=2.1P
+ PS=10.42U PD=10.42U
* device instance $582 r0 *1 650.37,648.04 nfet
M$582 OUT x3_lockout GND_DRV GND_LOGIC nfet L=0.7U W=10U AS=2.1P AD=2.1P
+ PS=10.42U PD=10.42U
* device instance $583 r0 *1 651.49,648.04 nfet
M$583 GND_DRV x3_lockout OUT GND_LOGIC nfet L=0.7U W=10U AS=2.1P AD=2.1P
+ PS=10.42U PD=10.42U
* device instance $584 r0 *1 652.61,648.04 nfet
M$584 OUT x3_lockout GND_DRV GND_LOGIC nfet L=0.7U W=10U AS=2.1P AD=2.1P
+ PS=10.42U PD=10.42U
* device instance $585 r0 *1 653.73,648.04 nfet
M$585 GND_DRV x3_lockout OUT GND_LOGIC nfet L=0.7U W=10U AS=2.1P AD=2.1P
+ PS=10.42U PD=10.42U
* device instance $586 r0 *1 654.85,648.04 nfet
M$586 OUT x3_lockout GND_DRV GND_LOGIC nfet L=0.7U W=10U AS=2.1P AD=2.1P
+ PS=10.42U PD=10.42U
* device instance $587 r0 *1 655.97,648.04 nfet
M$587 GND_DRV x3_lockout OUT GND_LOGIC nfet L=0.7U W=10U AS=2.1P AD=2.1P
+ PS=10.42U PD=10.42U
* device instance $588 r0 *1 657.09,648.04 nfet
M$588 OUT x3_lockout GND_DRV GND_LOGIC nfet L=0.7U W=10U AS=2.1P AD=2.1P
+ PS=10.42U PD=10.42U
* device instance $589 r0 *1 658.21,648.04 nfet
M$589 GND_DRV x3_lockout OUT GND_LOGIC nfet L=0.7U W=10U AS=2.1P AD=2.1P
+ PS=10.42U PD=10.42U
* device instance $590 r0 *1 659.33,648.04 nfet
M$590 OUT x3_lockout GND_DRV GND_LOGIC nfet L=0.7U W=10U AS=2.1P AD=2.1P
+ PS=10.42U PD=10.42U
* device instance $591 r0 *1 660.45,648.04 nfet
M$591 GND_DRV x3_lockout OUT GND_LOGIC nfet L=0.7U W=10U AS=2.1P AD=2.1P
+ PS=10.42U PD=10.42U
* device instance $592 r0 *1 661.57,648.04 nfet
M$592 OUT x3_lockout GND_DRV GND_LOGIC nfet L=0.7U W=10U AS=2.1P AD=2.1P
+ PS=10.42U PD=10.42U
* device instance $593 r0 *1 662.69,648.04 nfet
M$593 GND_DRV x3_lockout OUT GND_LOGIC nfet L=0.7U W=10U AS=2.1P AD=2.1P
+ PS=10.42U PD=10.42U
* device instance $594 r0 *1 663.81,648.04 nfet
M$594 OUT x3_lockout GND_DRV GND_LOGIC nfet L=0.7U W=10U AS=2.1P AD=2.1P
+ PS=10.42U PD=10.42U
* device instance $595 r0 *1 664.93,648.04 nfet
M$595 GND_DRV x3_lockout OUT GND_LOGIC nfet L=0.7U W=10U AS=2.1P AD=2.1P
+ PS=10.42U PD=10.42U
* device instance $596 r0 *1 666.05,648.04 nfet
M$596 OUT x3_lockout GND_DRV GND_LOGIC nfet L=0.7U W=10U AS=2.1P AD=2.1P
+ PS=10.42U PD=10.42U
* device instance $597 r0 *1 667.17,648.04 nfet
M$597 GND_DRV x3_lockout OUT GND_LOGIC nfet L=0.7U W=10U AS=2.1P AD=2.1P
+ PS=10.42U PD=10.42U
* device instance $598 r0 *1 668.29,648.04 nfet
M$598 OUT x3_lockout GND_DRV GND_LOGIC nfet L=0.7U W=10U AS=2.1P AD=2.1P
+ PS=10.42U PD=10.42U
* device instance $599 r0 *1 669.41,648.04 nfet
M$599 GND_DRV x3_lockout OUT GND_LOGIC nfet L=0.7U W=10U AS=2.1P AD=2.1P
+ PS=10.42U PD=10.42U
* device instance $600 r0 *1 670.53,648.04 nfet
M$600 OUT x3_lockout GND_DRV GND_LOGIC nfet L=0.7U W=10U AS=2.1P AD=2.1P
+ PS=10.42U PD=10.42U
* device instance $601 r0 *1 671.65,648.04 nfet
M$601 GND_DRV x3_lockout OUT GND_LOGIC nfet L=0.7U W=10U AS=2.1P AD=2.1P
+ PS=10.42U PD=10.42U
* device instance $602 r0 *1 448.77,648.04 nfet
M$602 OUT x3_lockout GND_DRV GND_LOGIC nfet L=0.7U W=10U AS=2.1P AD=2.1P
+ PS=10.42U PD=10.42U
* device instance $603 r0 *1 449.89,648.04 nfet
M$603 GND_DRV x3_lockout OUT GND_LOGIC nfet L=0.7U W=10U AS=2.1P AD=2.1P
+ PS=10.42U PD=10.42U
* device instance $604 r0 *1 451.01,648.04 nfet
M$604 OUT x3_lockout GND_DRV GND_LOGIC nfet L=0.7U W=10U AS=2.1P AD=2.1P
+ PS=10.42U PD=10.42U
* device instance $605 r0 *1 452.13,648.04 nfet
M$605 GND_DRV x3_lockout OUT GND_LOGIC nfet L=0.7U W=10U AS=2.1P AD=2.1P
+ PS=10.42U PD=10.42U
* device instance $606 r0 *1 453.25,648.04 nfet
M$606 OUT x3_lockout GND_DRV GND_LOGIC nfet L=0.7U W=10U AS=2.1P AD=2.1P
+ PS=10.42U PD=10.42U
* device instance $607 r0 *1 454.37,648.04 nfet
M$607 GND_DRV x3_lockout OUT GND_LOGIC nfet L=0.7U W=10U AS=2.1P AD=2.1P
+ PS=10.42U PD=10.42U
* device instance $608 r0 *1 455.49,648.04 nfet
M$608 OUT x3_lockout GND_DRV GND_LOGIC nfet L=0.7U W=10U AS=2.1P AD=2.1P
+ PS=10.42U PD=10.42U
* device instance $609 r0 *1 456.61,648.04 nfet
M$609 GND_DRV x3_lockout OUT GND_LOGIC nfet L=0.7U W=10U AS=2.1P AD=2.1P
+ PS=10.42U PD=10.42U
* device instance $610 r0 *1 457.73,648.04 nfet
M$610 OUT x3_lockout GND_DRV GND_LOGIC nfet L=0.7U W=10U AS=2.1P AD=2.1P
+ PS=10.42U PD=10.42U
* device instance $611 r0 *1 458.85,648.04 nfet
M$611 GND_DRV x3_lockout OUT GND_LOGIC nfet L=0.7U W=10U AS=2.1P AD=2.1P
+ PS=10.42U PD=10.42U
* device instance $612 r0 *1 459.97,648.04 nfet
M$612 OUT x3_lockout GND_DRV GND_LOGIC nfet L=0.7U W=10U AS=2.1P AD=2.1P
+ PS=10.42U PD=10.42U
* device instance $613 r0 *1 461.09,648.04 nfet
M$613 GND_DRV x3_lockout OUT GND_LOGIC nfet L=0.7U W=10U AS=2.1P AD=2.1P
+ PS=10.42U PD=10.42U
* device instance $614 r0 *1 462.21,648.04 nfet
M$614 OUT x3_lockout GND_DRV GND_LOGIC nfet L=0.7U W=10U AS=2.1P AD=2.1P
+ PS=10.42U PD=10.42U
* device instance $615 r0 *1 463.33,648.04 nfet
M$615 GND_DRV x3_lockout OUT GND_LOGIC nfet L=0.7U W=10U AS=2.1P AD=2.1P
+ PS=10.42U PD=10.42U
* device instance $616 r0 *1 464.45,648.04 nfet
M$616 OUT x3_lockout GND_DRV GND_LOGIC nfet L=0.7U W=10U AS=2.1P AD=2.1P
+ PS=10.42U PD=10.42U
* device instance $617 r0 *1 465.57,648.04 nfet
M$617 GND_DRV x3_lockout OUT GND_LOGIC nfet L=0.7U W=10U AS=2.1P AD=2.1P
+ PS=10.42U PD=10.42U
* device instance $618 r0 *1 466.69,648.04 nfet
M$618 OUT x3_lockout GND_DRV GND_LOGIC nfet L=0.7U W=10U AS=2.1P AD=2.1P
+ PS=10.42U PD=10.42U
* device instance $619 r0 *1 467.81,648.04 nfet
M$619 GND_DRV x3_lockout OUT GND_LOGIC nfet L=0.7U W=10U AS=2.1P AD=2.1P
+ PS=10.42U PD=10.42U
* device instance $620 r0 *1 468.93,648.04 nfet
M$620 OUT x3_lockout GND_DRV GND_LOGIC nfet L=0.7U W=10U AS=2.1P AD=2.1P
+ PS=10.42U PD=10.42U
* device instance $621 r0 *1 470.05,648.04 nfet
M$621 GND_DRV x3_lockout OUT GND_LOGIC nfet L=0.7U W=10U AS=2.1P AD=2.1P
+ PS=10.42U PD=10.42U
* device instance $622 r0 *1 471.17,648.04 nfet
M$622 OUT x3_lockout GND_DRV GND_LOGIC nfet L=0.7U W=10U AS=2.1P AD=2.1P
+ PS=10.42U PD=10.42U
* device instance $623 r0 *1 472.29,648.04 nfet
M$623 GND_DRV x3_lockout OUT GND_LOGIC nfet L=0.7U W=10U AS=2.1P AD=2.1P
+ PS=10.42U PD=10.42U
* device instance $624 r0 *1 473.41,648.04 nfet
M$624 OUT x3_lockout GND_DRV GND_LOGIC nfet L=0.7U W=10U AS=2.1P AD=2.1P
+ PS=10.42U PD=10.42U
* device instance $625 r0 *1 474.53,648.04 nfet
M$625 GND_DRV x3_lockout OUT GND_LOGIC nfet L=0.7U W=10U AS=2.1P AD=2.1P
+ PS=10.42U PD=10.42U
* device instance $626 r0 *1 475.65,648.04 nfet
M$626 OUT x3_lockout GND_DRV GND_LOGIC nfet L=0.7U W=10U AS=2.1P AD=2.1P
+ PS=10.42U PD=10.42U
* device instance $627 r0 *1 476.77,648.04 nfet
M$627 GND_DRV x3_lockout OUT GND_LOGIC nfet L=0.7U W=10U AS=2.1P AD=2.1P
+ PS=10.42U PD=10.42U
* device instance $628 r0 *1 477.89,648.04 nfet
M$628 OUT x3_lockout GND_DRV GND_LOGIC nfet L=0.7U W=10U AS=2.1P AD=2.1P
+ PS=10.42U PD=10.42U
* device instance $629 r0 *1 479.01,648.04 nfet
M$629 GND_DRV x3_lockout OUT GND_LOGIC nfet L=0.7U W=10U AS=2.1P AD=2.1P
+ PS=10.42U PD=10.42U
* device instance $630 r0 *1 480.13,648.04 nfet
M$630 OUT x3_lockout GND_DRV GND_LOGIC nfet L=0.7U W=10U AS=2.1P AD=2.1P
+ PS=10.42U PD=10.42U
* device instance $631 r0 *1 481.25,648.04 nfet
M$631 GND_DRV x3_lockout OUT GND_LOGIC nfet L=0.7U W=10U AS=2.1P AD=2.1P
+ PS=10.42U PD=10.42U
* device instance $632 r0 *1 482.37,648.04 nfet
M$632 OUT x3_lockout GND_DRV GND_LOGIC nfet L=0.7U W=10U AS=2.1P AD=2.1P
+ PS=10.42U PD=10.42U
* device instance $633 r0 *1 483.49,648.04 nfet
M$633 GND_DRV x3_lockout OUT GND_LOGIC nfet L=0.7U W=10U AS=2.1P AD=2.1P
+ PS=10.42U PD=10.42U
* device instance $634 r0 *1 484.61,648.04 nfet
M$634 OUT x3_lockout GND_DRV GND_LOGIC nfet L=0.7U W=10U AS=2.1P AD=2.1P
+ PS=10.42U PD=10.42U
* device instance $635 r0 *1 485.73,648.04 nfet
M$635 GND_DRV x3_lockout OUT GND_LOGIC nfet L=0.7U W=10U AS=2.1P AD=2.1P
+ PS=10.42U PD=10.42U
* device instance $636 r0 *1 486.85,648.04 nfet
M$636 OUT x3_lockout GND_DRV GND_LOGIC nfet L=0.7U W=10U AS=2.1P AD=2.1P
+ PS=10.42U PD=10.42U
* device instance $637 r0 *1 487.97,648.04 nfet
M$637 GND_DRV x3_lockout OUT GND_LOGIC nfet L=0.7U W=10U AS=2.1P AD=2.1P
+ PS=10.42U PD=10.42U
* device instance $638 r0 *1 489.09,648.04 nfet
M$638 OUT x3_lockout GND_DRV GND_LOGIC nfet L=0.7U W=10U AS=2.1P AD=2.1P
+ PS=10.42U PD=10.42U
* device instance $639 r0 *1 490.21,648.04 nfet
M$639 GND_DRV x3_lockout OUT GND_LOGIC nfet L=0.7U W=10U AS=2.1P AD=2.1P
+ PS=10.42U PD=10.42U
* device instance $640 r0 *1 491.33,648.04 nfet
M$640 OUT x3_lockout GND_DRV GND_LOGIC nfet L=0.7U W=10U AS=2.1P AD=2.1P
+ PS=10.42U PD=10.42U
* device instance $641 r0 *1 492.45,648.04 nfet
M$641 GND_DRV x3_lockout OUT GND_LOGIC nfet L=0.7U W=10U AS=2.1P AD=2.1P
+ PS=10.42U PD=10.42U
* device instance $642 r0 *1 493.57,648.04 nfet
M$642 OUT x3_lockout GND_DRV GND_LOGIC nfet L=0.7U W=10U AS=2.1P AD=2.1P
+ PS=10.42U PD=10.42U
* device instance $643 r0 *1 494.69,648.04 nfet
M$643 GND_DRV x3_lockout OUT GND_LOGIC nfet L=0.7U W=10U AS=2.1P AD=2.1P
+ PS=10.42U PD=10.42U
* device instance $644 r0 *1 495.81,648.04 nfet
M$644 OUT x3_lockout GND_DRV GND_LOGIC nfet L=0.7U W=10U AS=2.1P AD=2.1P
+ PS=10.42U PD=10.42U
* device instance $645 r0 *1 496.93,648.04 nfet
M$645 GND_DRV x3_lockout OUT GND_LOGIC nfet L=0.7U W=10U AS=2.1P AD=2.1P
+ PS=10.42U PD=10.42U
* device instance $646 r0 *1 498.05,648.04 nfet
M$646 OUT x3_lockout GND_DRV GND_LOGIC nfet L=0.7U W=10U AS=2.1P AD=2.1P
+ PS=10.42U PD=10.42U
* device instance $647 r0 *1 499.17,648.04 nfet
M$647 GND_DRV x3_lockout OUT GND_LOGIC nfet L=0.7U W=10U AS=2.1P AD=2.1P
+ PS=10.42U PD=10.42U
* device instance $648 r0 *1 500.29,648.04 nfet
M$648 OUT x3_lockout GND_DRV GND_LOGIC nfet L=0.7U W=10U AS=2.1P AD=2.1P
+ PS=10.42U PD=10.42U
* device instance $649 r0 *1 501.41,648.04 nfet
M$649 GND_DRV x3_lockout OUT GND_LOGIC nfet L=0.7U W=10U AS=2.1P AD=2.1P
+ PS=10.42U PD=10.42U
* device instance $650 r0 *1 502.53,648.04 nfet
M$650 OUT x3_lockout GND_DRV GND_LOGIC nfet L=0.7U W=10U AS=2.1P AD=2.1P
+ PS=10.42U PD=10.42U
* device instance $651 r0 *1 503.65,648.04 nfet
M$651 GND_DRV x3_lockout OUT GND_LOGIC nfet L=0.7U W=10U AS=2.1P AD=2.1P
+ PS=10.42U PD=10.42U
* device instance $652 r0 *1 504.77,648.04 nfet
M$652 OUT x3_lockout GND_DRV GND_LOGIC nfet L=0.7U W=10U AS=2.1P AD=2.1P
+ PS=10.42U PD=10.42U
* device instance $653 r0 *1 505.89,648.04 nfet
M$653 GND_DRV x3_lockout OUT GND_LOGIC nfet L=0.7U W=10U AS=2.1P AD=2.1P
+ PS=10.42U PD=10.42U
* device instance $654 r0 *1 507.01,648.04 nfet
M$654 OUT x3_lockout GND_DRV GND_LOGIC nfet L=0.7U W=10U AS=2.1P AD=2.1P
+ PS=10.42U PD=10.42U
* device instance $655 r0 *1 508.13,648.04 nfet
M$655 GND_DRV x3_lockout OUT GND_LOGIC nfet L=0.7U W=10U AS=2.1P AD=2.1P
+ PS=10.42U PD=10.42U
* device instance $656 r0 *1 509.25,648.04 nfet
M$656 OUT x3_lockout GND_DRV GND_LOGIC nfet L=0.7U W=10U AS=2.1P AD=2.1P
+ PS=10.42U PD=10.42U
* device instance $657 r0 *1 510.37,648.04 nfet
M$657 GND_DRV x3_lockout OUT GND_LOGIC nfet L=0.7U W=10U AS=2.1P AD=2.1P
+ PS=10.42U PD=10.42U
* device instance $658 r0 *1 511.49,648.04 nfet
M$658 OUT x3_lockout GND_DRV GND_LOGIC nfet L=0.7U W=10U AS=2.1P AD=2.1P
+ PS=10.42U PD=10.42U
* device instance $659 r0 *1 512.61,648.04 nfet
M$659 GND_DRV x3_lockout OUT GND_LOGIC nfet L=0.7U W=10U AS=2.1P AD=2.1P
+ PS=10.42U PD=10.42U
* device instance $660 r0 *1 513.73,648.04 nfet
M$660 OUT x3_lockout GND_DRV GND_LOGIC nfet L=0.7U W=10U AS=2.1P AD=2.1P
+ PS=10.42U PD=10.42U
* device instance $661 r0 *1 514.85,648.04 nfet
M$661 GND_DRV x3_lockout OUT GND_LOGIC nfet L=0.7U W=10U AS=2.1P AD=2.1P
+ PS=10.42U PD=10.42U
* device instance $662 r0 *1 515.97,648.04 nfet
M$662 OUT x3_lockout GND_DRV GND_LOGIC nfet L=0.7U W=10U AS=2.1P AD=2.1P
+ PS=10.42U PD=10.42U
* device instance $663 r0 *1 517.09,648.04 nfet
M$663 GND_DRV x3_lockout OUT GND_LOGIC nfet L=0.7U W=10U AS=2.1P AD=2.1P
+ PS=10.42U PD=10.42U
* device instance $664 r0 *1 518.21,648.04 nfet
M$664 OUT x3_lockout GND_DRV GND_LOGIC nfet L=0.7U W=10U AS=2.1P AD=2.1P
+ PS=10.42U PD=10.42U
* device instance $665 r0 *1 519.33,648.04 nfet
M$665 GND_DRV x3_lockout OUT GND_LOGIC nfet L=0.7U W=10U AS=2.1P AD=2.1P
+ PS=10.42U PD=10.42U
* device instance $666 r0 *1 520.45,648.04 nfet
M$666 OUT x3_lockout GND_DRV GND_LOGIC nfet L=0.7U W=10U AS=2.1P AD=2.1P
+ PS=10.42U PD=10.42U
* device instance $667 r0 *1 521.57,648.04 nfet
M$667 GND_DRV x3_lockout OUT GND_LOGIC nfet L=0.7U W=10U AS=2.1P AD=2.1P
+ PS=10.42U PD=10.42U
* device instance $668 r0 *1 522.69,648.04 nfet
M$668 OUT x3_lockout GND_DRV GND_LOGIC nfet L=0.7U W=10U AS=2.1P AD=2.1P
+ PS=10.42U PD=10.42U
* device instance $669 r0 *1 523.81,648.04 nfet
M$669 GND_DRV x3_lockout OUT GND_LOGIC nfet L=0.7U W=10U AS=2.1P AD=2.1P
+ PS=10.42U PD=10.42U
* device instance $670 r0 *1 524.93,648.04 nfet
M$670 OUT x3_lockout GND_DRV GND_LOGIC nfet L=0.7U W=10U AS=2.1P AD=2.1P
+ PS=10.42U PD=10.42U
* device instance $671 r0 *1 526.05,648.04 nfet
M$671 GND_DRV x3_lockout OUT GND_LOGIC nfet L=0.7U W=10U AS=2.1P AD=2.1P
+ PS=10.42U PD=10.42U
* device instance $672 r0 *1 527.17,648.04 nfet
M$672 OUT x3_lockout GND_DRV GND_LOGIC nfet L=0.7U W=10U AS=2.1P AD=2.1P
+ PS=10.42U PD=10.42U
* device instance $673 r0 *1 528.29,648.04 nfet
M$673 GND_DRV x3_lockout OUT GND_LOGIC nfet L=0.7U W=10U AS=2.1P AD=2.1P
+ PS=10.42U PD=10.42U
* device instance $674 r0 *1 529.41,648.04 nfet
M$674 OUT x3_lockout GND_DRV GND_LOGIC nfet L=0.7U W=10U AS=2.1P AD=2.1P
+ PS=10.42U PD=10.42U
* device instance $675 r0 *1 530.53,648.04 nfet
M$675 GND_DRV x3_lockout OUT GND_LOGIC nfet L=0.7U W=10U AS=2.1P AD=2.1P
+ PS=10.42U PD=10.42U
* device instance $676 r0 *1 531.65,648.04 nfet
M$676 OUT x3_lockout GND_DRV GND_LOGIC nfet L=0.7U W=10U AS=2.1P AD=2.1P
+ PS=10.42U PD=10.42U
* device instance $677 r0 *1 532.77,648.04 nfet
M$677 GND_DRV x3_lockout OUT GND_LOGIC nfet L=0.7U W=10U AS=2.1P AD=2.1P
+ PS=10.42U PD=10.42U
* device instance $678 r0 *1 533.89,648.04 nfet
M$678 OUT x3_lockout GND_DRV GND_LOGIC nfet L=0.7U W=10U AS=2.1P AD=2.1P
+ PS=10.42U PD=10.42U
* device instance $679 r0 *1 535.01,648.04 nfet
M$679 GND_DRV x3_lockout OUT GND_LOGIC nfet L=0.7U W=10U AS=2.1P AD=2.1P
+ PS=10.42U PD=10.42U
* device instance $680 r0 *1 536.13,648.04 nfet
M$680 OUT x3_lockout GND_DRV GND_LOGIC nfet L=0.7U W=10U AS=2.1P AD=2.1P
+ PS=10.42U PD=10.42U
* device instance $681 r0 *1 537.25,648.04 nfet
M$681 GND_DRV x3_lockout OUT GND_LOGIC nfet L=0.7U W=10U AS=2.1P AD=2.1P
+ PS=10.42U PD=10.42U
* device instance $682 r0 *1 538.37,648.04 nfet
M$682 OUT x3_lockout GND_DRV GND_LOGIC nfet L=0.7U W=10U AS=2.1P AD=2.1P
+ PS=10.42U PD=10.42U
* device instance $683 r0 *1 539.49,648.04 nfet
M$683 GND_DRV x3_lockout OUT GND_LOGIC nfet L=0.7U W=10U AS=2.1P AD=2.1P
+ PS=10.42U PD=10.42U
* device instance $684 r0 *1 540.61,648.04 nfet
M$684 OUT x3_lockout GND_DRV GND_LOGIC nfet L=0.7U W=10U AS=2.1P AD=2.1P
+ PS=10.42U PD=10.42U
* device instance $685 r0 *1 541.73,648.04 nfet
M$685 GND_DRV x3_lockout OUT GND_LOGIC nfet L=0.7U W=10U AS=2.1P AD=2.1P
+ PS=10.42U PD=10.42U
* device instance $686 r0 *1 542.85,648.04 nfet
M$686 OUT x3_lockout GND_DRV GND_LOGIC nfet L=0.7U W=10U AS=2.1P AD=2.1P
+ PS=10.42U PD=10.42U
* device instance $687 r0 *1 543.97,648.04 nfet
M$687 GND_DRV x3_lockout OUT GND_LOGIC nfet L=0.7U W=10U AS=2.1P AD=2.1P
+ PS=10.42U PD=10.42U
* device instance $688 r0 *1 545.09,648.04 nfet
M$688 OUT x3_lockout GND_DRV GND_LOGIC nfet L=0.7U W=10U AS=2.1P AD=2.1P
+ PS=10.42U PD=10.42U
* device instance $689 r0 *1 546.21,648.04 nfet
M$689 GND_DRV x3_lockout OUT GND_LOGIC nfet L=0.7U W=10U AS=2.1P AD=2.1P
+ PS=10.42U PD=10.42U
* device instance $690 r0 *1 547.33,648.04 nfet
M$690 OUT x3_lockout GND_DRV GND_LOGIC nfet L=0.7U W=10U AS=2.1P AD=2.1P
+ PS=10.42U PD=10.42U
* device instance $691 r0 *1 548.45,648.04 nfet
M$691 GND_DRV x3_lockout OUT GND_LOGIC nfet L=0.7U W=10U AS=2.1P AD=2.1P
+ PS=10.42U PD=10.42U
* device instance $692 r0 *1 549.57,648.04 nfet
M$692 OUT x3_lockout GND_DRV GND_LOGIC nfet L=0.7U W=10U AS=2.1P AD=2.1P
+ PS=10.42U PD=10.42U
* device instance $693 r0 *1 550.69,648.04 nfet
M$693 GND_DRV x3_lockout OUT GND_LOGIC nfet L=0.7U W=10U AS=2.1P AD=2.1P
+ PS=10.42U PD=10.42U
* device instance $694 r0 *1 551.81,648.04 nfet
M$694 OUT x3_lockout GND_DRV GND_LOGIC nfet L=0.7U W=10U AS=2.1P AD=2.1P
+ PS=10.42U PD=10.42U
* device instance $695 r0 *1 552.93,648.04 nfet
M$695 GND_DRV x3_lockout OUT GND_LOGIC nfet L=0.7U W=10U AS=2.1P AD=2.1P
+ PS=10.42U PD=10.42U
* device instance $696 r0 *1 554.05,648.04 nfet
M$696 OUT x3_lockout GND_DRV GND_LOGIC nfet L=0.7U W=10U AS=2.1P AD=2.1P
+ PS=10.42U PD=10.42U
* device instance $697 r0 *1 555.17,648.04 nfet
M$697 GND_DRV x3_lockout OUT GND_LOGIC nfet L=0.7U W=10U AS=2.1P AD=2.1P
+ PS=10.42U PD=10.42U
* device instance $698 r0 *1 556.29,648.04 nfet
M$698 OUT x3_lockout GND_DRV GND_LOGIC nfet L=0.7U W=10U AS=2.1P AD=2.1P
+ PS=10.42U PD=10.42U
* device instance $699 r0 *1 557.41,648.04 nfet
M$699 GND_DRV x3_lockout OUT GND_LOGIC nfet L=0.7U W=10U AS=2.1P AD=2.1P
+ PS=10.42U PD=10.42U
* device instance $700 r0 *1 558.53,648.04 nfet
M$700 OUT x3_lockout GND_DRV GND_LOGIC nfet L=0.7U W=10U AS=2.1P AD=2.1P
+ PS=10.42U PD=10.42U
* device instance $701 r0 *1 559.65,648.04 nfet
M$701 GND_DRV x3_lockout OUT GND_LOGIC nfet L=0.7U W=10U AS=2.1P AD=2.1P
+ PS=10.42U PD=10.42U
* device instance $702 r0 *1 336.77,648.04 nfet
M$702 OUT x3_lockout GND_DRV GND_LOGIC nfet L=0.7U W=10U AS=2.1P AD=2.1P
+ PS=10.42U PD=10.42U
* device instance $703 r0 *1 337.89,648.04 nfet
M$703 GND_DRV x3_lockout OUT GND_LOGIC nfet L=0.7U W=10U AS=2.1P AD=2.1P
+ PS=10.42U PD=10.42U
* device instance $704 r0 *1 339.01,648.04 nfet
M$704 OUT x3_lockout GND_DRV GND_LOGIC nfet L=0.7U W=10U AS=2.1P AD=2.1P
+ PS=10.42U PD=10.42U
* device instance $705 r0 *1 340.13,648.04 nfet
M$705 GND_DRV x3_lockout OUT GND_LOGIC nfet L=0.7U W=10U AS=2.1P AD=2.1P
+ PS=10.42U PD=10.42U
* device instance $706 r0 *1 341.25,648.04 nfet
M$706 OUT x3_lockout GND_DRV GND_LOGIC nfet L=0.7U W=10U AS=2.1P AD=2.1P
+ PS=10.42U PD=10.42U
* device instance $707 r0 *1 342.37,648.04 nfet
M$707 GND_DRV x3_lockout OUT GND_LOGIC nfet L=0.7U W=10U AS=2.1P AD=2.1P
+ PS=10.42U PD=10.42U
* device instance $708 r0 *1 343.49,648.04 nfet
M$708 OUT x3_lockout GND_DRV GND_LOGIC nfet L=0.7U W=10U AS=2.1P AD=2.1P
+ PS=10.42U PD=10.42U
* device instance $709 r0 *1 344.61,648.04 nfet
M$709 GND_DRV x3_lockout OUT GND_LOGIC nfet L=0.7U W=10U AS=2.1P AD=2.1P
+ PS=10.42U PD=10.42U
* device instance $710 r0 *1 345.73,648.04 nfet
M$710 OUT x3_lockout GND_DRV GND_LOGIC nfet L=0.7U W=10U AS=2.1P AD=2.1P
+ PS=10.42U PD=10.42U
* device instance $711 r0 *1 346.85,648.04 nfet
M$711 GND_DRV x3_lockout OUT GND_LOGIC nfet L=0.7U W=10U AS=2.1P AD=2.1P
+ PS=10.42U PD=10.42U
* device instance $712 r0 *1 347.97,648.04 nfet
M$712 OUT x3_lockout GND_DRV GND_LOGIC nfet L=0.7U W=10U AS=2.1P AD=2.1P
+ PS=10.42U PD=10.42U
* device instance $713 r0 *1 349.09,648.04 nfet
M$713 GND_DRV x3_lockout OUT GND_LOGIC nfet L=0.7U W=10U AS=2.1P AD=2.1P
+ PS=10.42U PD=10.42U
* device instance $714 r0 *1 350.21,648.04 nfet
M$714 OUT x3_lockout GND_DRV GND_LOGIC nfet L=0.7U W=10U AS=2.1P AD=2.1P
+ PS=10.42U PD=10.42U
* device instance $715 r0 *1 351.33,648.04 nfet
M$715 GND_DRV x3_lockout OUT GND_LOGIC nfet L=0.7U W=10U AS=2.1P AD=2.1P
+ PS=10.42U PD=10.42U
* device instance $716 r0 *1 352.45,648.04 nfet
M$716 OUT x3_lockout GND_DRV GND_LOGIC nfet L=0.7U W=10U AS=2.1P AD=2.1P
+ PS=10.42U PD=10.42U
* device instance $717 r0 *1 353.57,648.04 nfet
M$717 GND_DRV x3_lockout OUT GND_LOGIC nfet L=0.7U W=10U AS=2.1P AD=2.1P
+ PS=10.42U PD=10.42U
* device instance $718 r0 *1 354.69,648.04 nfet
M$718 OUT x3_lockout GND_DRV GND_LOGIC nfet L=0.7U W=10U AS=2.1P AD=2.1P
+ PS=10.42U PD=10.42U
* device instance $719 r0 *1 355.81,648.04 nfet
M$719 GND_DRV x3_lockout OUT GND_LOGIC nfet L=0.7U W=10U AS=2.1P AD=2.1P
+ PS=10.42U PD=10.42U
* device instance $720 r0 *1 356.93,648.04 nfet
M$720 OUT x3_lockout GND_DRV GND_LOGIC nfet L=0.7U W=10U AS=2.1P AD=2.1P
+ PS=10.42U PD=10.42U
* device instance $721 r0 *1 358.05,648.04 nfet
M$721 GND_DRV x3_lockout OUT GND_LOGIC nfet L=0.7U W=10U AS=2.1P AD=2.1P
+ PS=10.42U PD=10.42U
* device instance $722 r0 *1 359.17,648.04 nfet
M$722 OUT x3_lockout GND_DRV GND_LOGIC nfet L=0.7U W=10U AS=2.1P AD=2.1P
+ PS=10.42U PD=10.42U
* device instance $723 r0 *1 360.29,648.04 nfet
M$723 GND_DRV x3_lockout OUT GND_LOGIC nfet L=0.7U W=10U AS=2.1P AD=2.1P
+ PS=10.42U PD=10.42U
* device instance $724 r0 *1 361.41,648.04 nfet
M$724 OUT x3_lockout GND_DRV GND_LOGIC nfet L=0.7U W=10U AS=2.1P AD=2.1P
+ PS=10.42U PD=10.42U
* device instance $725 r0 *1 362.53,648.04 nfet
M$725 GND_DRV x3_lockout OUT GND_LOGIC nfet L=0.7U W=10U AS=2.1P AD=2.1P
+ PS=10.42U PD=10.42U
* device instance $726 r0 *1 363.65,648.04 nfet
M$726 OUT x3_lockout GND_DRV GND_LOGIC nfet L=0.7U W=10U AS=2.1P AD=2.1P
+ PS=10.42U PD=10.42U
* device instance $727 r0 *1 364.77,648.04 nfet
M$727 GND_DRV x3_lockout OUT GND_LOGIC nfet L=0.7U W=10U AS=2.1P AD=2.1P
+ PS=10.42U PD=10.42U
* device instance $728 r0 *1 365.89,648.04 nfet
M$728 OUT x3_lockout GND_DRV GND_LOGIC nfet L=0.7U W=10U AS=2.1P AD=2.1P
+ PS=10.42U PD=10.42U
* device instance $729 r0 *1 367.01,648.04 nfet
M$729 GND_DRV x3_lockout OUT GND_LOGIC nfet L=0.7U W=10U AS=2.1P AD=2.1P
+ PS=10.42U PD=10.42U
* device instance $730 r0 *1 368.13,648.04 nfet
M$730 OUT x3_lockout GND_DRV GND_LOGIC nfet L=0.7U W=10U AS=2.1P AD=2.1P
+ PS=10.42U PD=10.42U
* device instance $731 r0 *1 369.25,648.04 nfet
M$731 GND_DRV x3_lockout OUT GND_LOGIC nfet L=0.7U W=10U AS=2.1P AD=2.1P
+ PS=10.42U PD=10.42U
* device instance $732 r0 *1 370.37,648.04 nfet
M$732 OUT x3_lockout GND_DRV GND_LOGIC nfet L=0.7U W=10U AS=2.1P AD=2.1P
+ PS=10.42U PD=10.42U
* device instance $733 r0 *1 371.49,648.04 nfet
M$733 GND_DRV x3_lockout OUT GND_LOGIC nfet L=0.7U W=10U AS=2.1P AD=2.1P
+ PS=10.42U PD=10.42U
* device instance $734 r0 *1 372.61,648.04 nfet
M$734 OUT x3_lockout GND_DRV GND_LOGIC nfet L=0.7U W=10U AS=2.1P AD=2.1P
+ PS=10.42U PD=10.42U
* device instance $735 r0 *1 373.73,648.04 nfet
M$735 GND_DRV x3_lockout OUT GND_LOGIC nfet L=0.7U W=10U AS=2.1P AD=2.1P
+ PS=10.42U PD=10.42U
* device instance $736 r0 *1 374.85,648.04 nfet
M$736 OUT x3_lockout GND_DRV GND_LOGIC nfet L=0.7U W=10U AS=2.1P AD=2.1P
+ PS=10.42U PD=10.42U
* device instance $737 r0 *1 375.97,648.04 nfet
M$737 GND_DRV x3_lockout OUT GND_LOGIC nfet L=0.7U W=10U AS=2.1P AD=2.1P
+ PS=10.42U PD=10.42U
* device instance $738 r0 *1 377.09,648.04 nfet
M$738 OUT x3_lockout GND_DRV GND_LOGIC nfet L=0.7U W=10U AS=2.1P AD=2.1P
+ PS=10.42U PD=10.42U
* device instance $739 r0 *1 378.21,648.04 nfet
M$739 GND_DRV x3_lockout OUT GND_LOGIC nfet L=0.7U W=10U AS=2.1P AD=2.1P
+ PS=10.42U PD=10.42U
* device instance $740 r0 *1 379.33,648.04 nfet
M$740 OUT x3_lockout GND_DRV GND_LOGIC nfet L=0.7U W=10U AS=2.1P AD=2.1P
+ PS=10.42U PD=10.42U
* device instance $741 r0 *1 380.45,648.04 nfet
M$741 GND_DRV x3_lockout OUT GND_LOGIC nfet L=0.7U W=10U AS=2.1P AD=2.1P
+ PS=10.42U PD=10.42U
* device instance $742 r0 *1 381.57,648.04 nfet
M$742 OUT x3_lockout GND_DRV GND_LOGIC nfet L=0.7U W=10U AS=2.1P AD=2.1P
+ PS=10.42U PD=10.42U
* device instance $743 r0 *1 382.69,648.04 nfet
M$743 GND_DRV x3_lockout OUT GND_LOGIC nfet L=0.7U W=10U AS=2.1P AD=2.1P
+ PS=10.42U PD=10.42U
* device instance $744 r0 *1 383.81,648.04 nfet
M$744 OUT x3_lockout GND_DRV GND_LOGIC nfet L=0.7U W=10U AS=2.1P AD=2.1P
+ PS=10.42U PD=10.42U
* device instance $745 r0 *1 384.93,648.04 nfet
M$745 GND_DRV x3_lockout OUT GND_LOGIC nfet L=0.7U W=10U AS=2.1P AD=2.1P
+ PS=10.42U PD=10.42U
* device instance $746 r0 *1 386.05,648.04 nfet
M$746 OUT x3_lockout GND_DRV GND_LOGIC nfet L=0.7U W=10U AS=2.1P AD=2.1P
+ PS=10.42U PD=10.42U
* device instance $747 r0 *1 387.17,648.04 nfet
M$747 GND_DRV x3_lockout OUT GND_LOGIC nfet L=0.7U W=10U AS=2.1P AD=2.1P
+ PS=10.42U PD=10.42U
* device instance $748 r0 *1 388.29,648.04 nfet
M$748 OUT x3_lockout GND_DRV GND_LOGIC nfet L=0.7U W=10U AS=2.1P AD=2.1P
+ PS=10.42U PD=10.42U
* device instance $749 r0 *1 389.41,648.04 nfet
M$749 GND_DRV x3_lockout OUT GND_LOGIC nfet L=0.7U W=10U AS=2.1P AD=2.1P
+ PS=10.42U PD=10.42U
* device instance $750 r0 *1 390.53,648.04 nfet
M$750 OUT x3_lockout GND_DRV GND_LOGIC nfet L=0.7U W=10U AS=2.1P AD=2.1P
+ PS=10.42U PD=10.42U
* device instance $751 r0 *1 391.65,648.04 nfet
M$751 GND_DRV x3_lockout OUT GND_LOGIC nfet L=0.7U W=10U AS=2.1P AD=2.1P
+ PS=10.42U PD=10.42U
* device instance $752 r0 *1 392.77,648.04 nfet
M$752 OUT x3_lockout GND_DRV GND_LOGIC nfet L=0.7U W=10U AS=2.1P AD=2.1P
+ PS=10.42U PD=10.42U
* device instance $753 r0 *1 393.89,648.04 nfet
M$753 GND_DRV x3_lockout OUT GND_LOGIC nfet L=0.7U W=10U AS=2.1P AD=2.1P
+ PS=10.42U PD=10.42U
* device instance $754 r0 *1 395.01,648.04 nfet
M$754 OUT x3_lockout GND_DRV GND_LOGIC nfet L=0.7U W=10U AS=2.1P AD=2.1P
+ PS=10.42U PD=10.42U
* device instance $755 r0 *1 396.13,648.04 nfet
M$755 GND_DRV x3_lockout OUT GND_LOGIC nfet L=0.7U W=10U AS=2.1P AD=2.1P
+ PS=10.42U PD=10.42U
* device instance $756 r0 *1 397.25,648.04 nfet
M$756 OUT x3_lockout GND_DRV GND_LOGIC nfet L=0.7U W=10U AS=2.1P AD=2.1P
+ PS=10.42U PD=10.42U
* device instance $757 r0 *1 398.37,648.04 nfet
M$757 GND_DRV x3_lockout OUT GND_LOGIC nfet L=0.7U W=10U AS=2.1P AD=2.1P
+ PS=10.42U PD=10.42U
* device instance $758 r0 *1 399.49,648.04 nfet
M$758 OUT x3_lockout GND_DRV GND_LOGIC nfet L=0.7U W=10U AS=2.1P AD=2.1P
+ PS=10.42U PD=10.42U
* device instance $759 r0 *1 400.61,648.04 nfet
M$759 GND_DRV x3_lockout OUT GND_LOGIC nfet L=0.7U W=10U AS=2.1P AD=2.1P
+ PS=10.42U PD=10.42U
* device instance $760 r0 *1 401.73,648.04 nfet
M$760 OUT x3_lockout GND_DRV GND_LOGIC nfet L=0.7U W=10U AS=2.1P AD=2.1P
+ PS=10.42U PD=10.42U
* device instance $761 r0 *1 402.85,648.04 nfet
M$761 GND_DRV x3_lockout OUT GND_LOGIC nfet L=0.7U W=10U AS=2.1P AD=2.1P
+ PS=10.42U PD=10.42U
* device instance $762 r0 *1 403.97,648.04 nfet
M$762 OUT x3_lockout GND_DRV GND_LOGIC nfet L=0.7U W=10U AS=2.1P AD=2.1P
+ PS=10.42U PD=10.42U
* device instance $763 r0 *1 405.09,648.04 nfet
M$763 GND_DRV x3_lockout OUT GND_LOGIC nfet L=0.7U W=10U AS=2.1P AD=2.1P
+ PS=10.42U PD=10.42U
* device instance $764 r0 *1 406.21,648.04 nfet
M$764 OUT x3_lockout GND_DRV GND_LOGIC nfet L=0.7U W=10U AS=2.1P AD=2.1P
+ PS=10.42U PD=10.42U
* device instance $765 r0 *1 407.33,648.04 nfet
M$765 GND_DRV x3_lockout OUT GND_LOGIC nfet L=0.7U W=10U AS=2.1P AD=2.1P
+ PS=10.42U PD=10.42U
* device instance $766 r0 *1 408.45,648.04 nfet
M$766 OUT x3_lockout GND_DRV GND_LOGIC nfet L=0.7U W=10U AS=2.1P AD=2.1P
+ PS=10.42U PD=10.42U
* device instance $767 r0 *1 409.57,648.04 nfet
M$767 GND_DRV x3_lockout OUT GND_LOGIC nfet L=0.7U W=10U AS=2.1P AD=2.1P
+ PS=10.42U PD=10.42U
* device instance $768 r0 *1 410.69,648.04 nfet
M$768 OUT x3_lockout GND_DRV GND_LOGIC nfet L=0.7U W=10U AS=2.1P AD=2.1P
+ PS=10.42U PD=10.42U
* device instance $769 r0 *1 411.81,648.04 nfet
M$769 GND_DRV x3_lockout OUT GND_LOGIC nfet L=0.7U W=10U AS=2.1P AD=2.1P
+ PS=10.42U PD=10.42U
* device instance $770 r0 *1 412.93,648.04 nfet
M$770 OUT x3_lockout GND_DRV GND_LOGIC nfet L=0.7U W=10U AS=2.1P AD=2.1P
+ PS=10.42U PD=10.42U
* device instance $771 r0 *1 414.05,648.04 nfet
M$771 GND_DRV x3_lockout OUT GND_LOGIC nfet L=0.7U W=10U AS=2.1P AD=2.1P
+ PS=10.42U PD=10.42U
* device instance $772 r0 *1 415.17,648.04 nfet
M$772 OUT x3_lockout GND_DRV GND_LOGIC nfet L=0.7U W=10U AS=2.1P AD=2.1P
+ PS=10.42U PD=10.42U
* device instance $773 r0 *1 416.29,648.04 nfet
M$773 GND_DRV x3_lockout OUT GND_LOGIC nfet L=0.7U W=10U AS=2.1P AD=2.1P
+ PS=10.42U PD=10.42U
* device instance $774 r0 *1 417.41,648.04 nfet
M$774 OUT x3_lockout GND_DRV GND_LOGIC nfet L=0.7U W=10U AS=2.1P AD=2.1P
+ PS=10.42U PD=10.42U
* device instance $775 r0 *1 418.53,648.04 nfet
M$775 GND_DRV x3_lockout OUT GND_LOGIC nfet L=0.7U W=10U AS=2.1P AD=2.1P
+ PS=10.42U PD=10.42U
* device instance $776 r0 *1 419.65,648.04 nfet
M$776 OUT x3_lockout GND_DRV GND_LOGIC nfet L=0.7U W=10U AS=2.1P AD=2.1P
+ PS=10.42U PD=10.42U
* device instance $777 r0 *1 420.77,648.04 nfet
M$777 GND_DRV x3_lockout OUT GND_LOGIC nfet L=0.7U W=10U AS=2.1P AD=2.1P
+ PS=10.42U PD=10.42U
* device instance $778 r0 *1 421.89,648.04 nfet
M$778 OUT x3_lockout GND_DRV GND_LOGIC nfet L=0.7U W=10U AS=2.1P AD=2.1P
+ PS=10.42U PD=10.42U
* device instance $779 r0 *1 423.01,648.04 nfet
M$779 GND_DRV x3_lockout OUT GND_LOGIC nfet L=0.7U W=10U AS=2.1P AD=2.1P
+ PS=10.42U PD=10.42U
* device instance $780 r0 *1 424.13,648.04 nfet
M$780 OUT x3_lockout GND_DRV GND_LOGIC nfet L=0.7U W=10U AS=2.1P AD=2.1P
+ PS=10.42U PD=10.42U
* device instance $781 r0 *1 425.25,648.04 nfet
M$781 GND_DRV x3_lockout OUT GND_LOGIC nfet L=0.7U W=10U AS=2.1P AD=2.1P
+ PS=10.42U PD=10.42U
* device instance $782 r0 *1 426.37,648.04 nfet
M$782 OUT x3_lockout GND_DRV GND_LOGIC nfet L=0.7U W=10U AS=2.1P AD=2.1P
+ PS=10.42U PD=10.42U
* device instance $783 r0 *1 427.49,648.04 nfet
M$783 GND_DRV x3_lockout OUT GND_LOGIC nfet L=0.7U W=10U AS=2.1P AD=2.1P
+ PS=10.42U PD=10.42U
* device instance $784 r0 *1 428.61,648.04 nfet
M$784 OUT x3_lockout GND_DRV GND_LOGIC nfet L=0.7U W=10U AS=2.1P AD=2.1P
+ PS=10.42U PD=10.42U
* device instance $785 r0 *1 429.73,648.04 nfet
M$785 GND_DRV x3_lockout OUT GND_LOGIC nfet L=0.7U W=10U AS=2.1P AD=2.1P
+ PS=10.42U PD=10.42U
* device instance $786 r0 *1 430.85,648.04 nfet
M$786 OUT x3_lockout GND_DRV GND_LOGIC nfet L=0.7U W=10U AS=2.1P AD=2.1P
+ PS=10.42U PD=10.42U
* device instance $787 r0 *1 431.97,648.04 nfet
M$787 GND_DRV x3_lockout OUT GND_LOGIC nfet L=0.7U W=10U AS=2.1P AD=2.1P
+ PS=10.42U PD=10.42U
* device instance $788 r0 *1 433.09,648.04 nfet
M$788 OUT x3_lockout GND_DRV GND_LOGIC nfet L=0.7U W=10U AS=2.1P AD=2.1P
+ PS=10.42U PD=10.42U
* device instance $789 r0 *1 434.21,648.04 nfet
M$789 GND_DRV x3_lockout OUT GND_LOGIC nfet L=0.7U W=10U AS=2.1P AD=2.1P
+ PS=10.42U PD=10.42U
* device instance $790 r0 *1 435.33,648.04 nfet
M$790 OUT x3_lockout GND_DRV GND_LOGIC nfet L=0.7U W=10U AS=2.1P AD=2.1P
+ PS=10.42U PD=10.42U
* device instance $791 r0 *1 436.45,648.04 nfet
M$791 GND_DRV x3_lockout OUT GND_LOGIC nfet L=0.7U W=10U AS=2.1P AD=2.1P
+ PS=10.42U PD=10.42U
* device instance $792 r0 *1 437.57,648.04 nfet
M$792 OUT x3_lockout GND_DRV GND_LOGIC nfet L=0.7U W=10U AS=2.1P AD=2.1P
+ PS=10.42U PD=10.42U
* device instance $793 r0 *1 438.69,648.04 nfet
M$793 GND_DRV x3_lockout OUT GND_LOGIC nfet L=0.7U W=10U AS=2.1P AD=2.1P
+ PS=10.42U PD=10.42U
* device instance $794 r0 *1 439.81,648.04 nfet
M$794 OUT x3_lockout GND_DRV GND_LOGIC nfet L=0.7U W=10U AS=2.1P AD=2.1P
+ PS=10.42U PD=10.42U
* device instance $795 r0 *1 440.93,648.04 nfet
M$795 GND_DRV x3_lockout OUT GND_LOGIC nfet L=0.7U W=10U AS=2.1P AD=2.1P
+ PS=10.42U PD=10.42U
* device instance $796 r0 *1 442.05,648.04 nfet
M$796 OUT x3_lockout GND_DRV GND_LOGIC nfet L=0.7U W=10U AS=2.1P AD=2.1P
+ PS=10.42U PD=10.42U
* device instance $797 r0 *1 443.17,648.04 nfet
M$797 GND_DRV x3_lockout OUT GND_LOGIC nfet L=0.7U W=10U AS=2.1P AD=2.1P
+ PS=10.42U PD=10.42U
* device instance $798 r0 *1 444.29,648.04 nfet
M$798 OUT x3_lockout GND_DRV GND_LOGIC nfet L=0.7U W=10U AS=2.1P AD=2.1P
+ PS=10.42U PD=10.42U
* device instance $799 r0 *1 445.41,648.04 nfet
M$799 GND_DRV x3_lockout OUT GND_LOGIC nfet L=0.7U W=10U AS=2.1P AD=2.1P
+ PS=10.42U PD=10.42U
* device instance $800 r0 *1 446.53,648.04 nfet
M$800 OUT x3_lockout GND_DRV GND_LOGIC nfet L=0.7U W=10U AS=2.1P AD=2.1P
+ PS=10.42U PD=10.42U
* device instance $801 r0 *1 447.65,648.04 nfet
M$801 GND_DRV x3_lockout OUT GND_LOGIC nfet L=0.7U W=10U AS=2.1P AD=2.1P
+ PS=10.42U PD=10.42U
* device instance $802 r0 *1 224.77,648.04 nfet
M$802 OUT x3_lockout GND_DRV GND_LOGIC nfet L=0.7U W=10U AS=2.1P AD=2.1P
+ PS=10.42U PD=10.42U
* device instance $803 r0 *1 225.89,648.04 nfet
M$803 GND_DRV x3_lockout OUT GND_LOGIC nfet L=0.7U W=10U AS=2.1P AD=2.1P
+ PS=10.42U PD=10.42U
* device instance $804 r0 *1 227.01,648.04 nfet
M$804 OUT x3_lockout GND_DRV GND_LOGIC nfet L=0.7U W=10U AS=2.1P AD=2.1P
+ PS=10.42U PD=10.42U
* device instance $805 r0 *1 228.13,648.04 nfet
M$805 GND_DRV x3_lockout OUT GND_LOGIC nfet L=0.7U W=10U AS=2.1P AD=2.1P
+ PS=10.42U PD=10.42U
* device instance $806 r0 *1 229.25,648.04 nfet
M$806 OUT x3_lockout GND_DRV GND_LOGIC nfet L=0.7U W=10U AS=2.1P AD=2.1P
+ PS=10.42U PD=10.42U
* device instance $807 r0 *1 230.37,648.04 nfet
M$807 GND_DRV x3_lockout OUT GND_LOGIC nfet L=0.7U W=10U AS=2.1P AD=2.1P
+ PS=10.42U PD=10.42U
* device instance $808 r0 *1 231.49,648.04 nfet
M$808 OUT x3_lockout GND_DRV GND_LOGIC nfet L=0.7U W=10U AS=2.1P AD=2.1P
+ PS=10.42U PD=10.42U
* device instance $809 r0 *1 232.61,648.04 nfet
M$809 GND_DRV x3_lockout OUT GND_LOGIC nfet L=0.7U W=10U AS=2.1P AD=2.1P
+ PS=10.42U PD=10.42U
* device instance $810 r0 *1 233.73,648.04 nfet
M$810 OUT x3_lockout GND_DRV GND_LOGIC nfet L=0.7U W=10U AS=2.1P AD=2.1P
+ PS=10.42U PD=10.42U
* device instance $811 r0 *1 234.85,648.04 nfet
M$811 GND_DRV x3_lockout OUT GND_LOGIC nfet L=0.7U W=10U AS=2.1P AD=2.1P
+ PS=10.42U PD=10.42U
* device instance $812 r0 *1 235.97,648.04 nfet
M$812 OUT x3_lockout GND_DRV GND_LOGIC nfet L=0.7U W=10U AS=2.1P AD=2.1P
+ PS=10.42U PD=10.42U
* device instance $813 r0 *1 237.09,648.04 nfet
M$813 GND_DRV x3_lockout OUT GND_LOGIC nfet L=0.7U W=10U AS=2.1P AD=2.1P
+ PS=10.42U PD=10.42U
* device instance $814 r0 *1 238.21,648.04 nfet
M$814 OUT x3_lockout GND_DRV GND_LOGIC nfet L=0.7U W=10U AS=2.1P AD=2.1P
+ PS=10.42U PD=10.42U
* device instance $815 r0 *1 239.33,648.04 nfet
M$815 GND_DRV x3_lockout OUT GND_LOGIC nfet L=0.7U W=10U AS=2.1P AD=2.1P
+ PS=10.42U PD=10.42U
* device instance $816 r0 *1 240.45,648.04 nfet
M$816 OUT x3_lockout GND_DRV GND_LOGIC nfet L=0.7U W=10U AS=2.1P AD=2.1P
+ PS=10.42U PD=10.42U
* device instance $817 r0 *1 241.57,648.04 nfet
M$817 GND_DRV x3_lockout OUT GND_LOGIC nfet L=0.7U W=10U AS=2.1P AD=2.1P
+ PS=10.42U PD=10.42U
* device instance $818 r0 *1 242.69,648.04 nfet
M$818 OUT x3_lockout GND_DRV GND_LOGIC nfet L=0.7U W=10U AS=2.1P AD=2.1P
+ PS=10.42U PD=10.42U
* device instance $819 r0 *1 243.81,648.04 nfet
M$819 GND_DRV x3_lockout OUT GND_LOGIC nfet L=0.7U W=10U AS=2.1P AD=2.1P
+ PS=10.42U PD=10.42U
* device instance $820 r0 *1 244.93,648.04 nfet
M$820 OUT x3_lockout GND_DRV GND_LOGIC nfet L=0.7U W=10U AS=2.1P AD=2.1P
+ PS=10.42U PD=10.42U
* device instance $821 r0 *1 246.05,648.04 nfet
M$821 GND_DRV x3_lockout OUT GND_LOGIC nfet L=0.7U W=10U AS=2.1P AD=2.1P
+ PS=10.42U PD=10.42U
* device instance $822 r0 *1 247.17,648.04 nfet
M$822 OUT x3_lockout GND_DRV GND_LOGIC nfet L=0.7U W=10U AS=2.1P AD=2.1P
+ PS=10.42U PD=10.42U
* device instance $823 r0 *1 248.29,648.04 nfet
M$823 GND_DRV x3_lockout OUT GND_LOGIC nfet L=0.7U W=10U AS=2.1P AD=2.1P
+ PS=10.42U PD=10.42U
* device instance $824 r0 *1 249.41,648.04 nfet
M$824 OUT x3_lockout GND_DRV GND_LOGIC nfet L=0.7U W=10U AS=2.1P AD=2.1P
+ PS=10.42U PD=10.42U
* device instance $825 r0 *1 250.53,648.04 nfet
M$825 GND_DRV x3_lockout OUT GND_LOGIC nfet L=0.7U W=10U AS=2.1P AD=2.1P
+ PS=10.42U PD=10.42U
* device instance $826 r0 *1 251.65,648.04 nfet
M$826 OUT x3_lockout GND_DRV GND_LOGIC nfet L=0.7U W=10U AS=2.1P AD=2.1P
+ PS=10.42U PD=10.42U
* device instance $827 r0 *1 252.77,648.04 nfet
M$827 GND_DRV x3_lockout OUT GND_LOGIC nfet L=0.7U W=10U AS=2.1P AD=2.1P
+ PS=10.42U PD=10.42U
* device instance $828 r0 *1 253.89,648.04 nfet
M$828 OUT x3_lockout GND_DRV GND_LOGIC nfet L=0.7U W=10U AS=2.1P AD=2.1P
+ PS=10.42U PD=10.42U
* device instance $829 r0 *1 255.01,648.04 nfet
M$829 GND_DRV x3_lockout OUT GND_LOGIC nfet L=0.7U W=10U AS=2.1P AD=2.1P
+ PS=10.42U PD=10.42U
* device instance $830 r0 *1 256.13,648.04 nfet
M$830 OUT x3_lockout GND_DRV GND_LOGIC nfet L=0.7U W=10U AS=2.1P AD=2.1P
+ PS=10.42U PD=10.42U
* device instance $831 r0 *1 257.25,648.04 nfet
M$831 GND_DRV x3_lockout OUT GND_LOGIC nfet L=0.7U W=10U AS=2.1P AD=2.1P
+ PS=10.42U PD=10.42U
* device instance $832 r0 *1 258.37,648.04 nfet
M$832 OUT x3_lockout GND_DRV GND_LOGIC nfet L=0.7U W=10U AS=2.1P AD=2.1P
+ PS=10.42U PD=10.42U
* device instance $833 r0 *1 259.49,648.04 nfet
M$833 GND_DRV x3_lockout OUT GND_LOGIC nfet L=0.7U W=10U AS=2.1P AD=2.1P
+ PS=10.42U PD=10.42U
* device instance $834 r0 *1 260.61,648.04 nfet
M$834 OUT x3_lockout GND_DRV GND_LOGIC nfet L=0.7U W=10U AS=2.1P AD=2.1P
+ PS=10.42U PD=10.42U
* device instance $835 r0 *1 261.73,648.04 nfet
M$835 GND_DRV x3_lockout OUT GND_LOGIC nfet L=0.7U W=10U AS=2.1P AD=2.1P
+ PS=10.42U PD=10.42U
* device instance $836 r0 *1 262.85,648.04 nfet
M$836 OUT x3_lockout GND_DRV GND_LOGIC nfet L=0.7U W=10U AS=2.1P AD=2.1P
+ PS=10.42U PD=10.42U
* device instance $837 r0 *1 263.97,648.04 nfet
M$837 GND_DRV x3_lockout OUT GND_LOGIC nfet L=0.7U W=10U AS=2.1P AD=2.1P
+ PS=10.42U PD=10.42U
* device instance $838 r0 *1 265.09,648.04 nfet
M$838 OUT x3_lockout GND_DRV GND_LOGIC nfet L=0.7U W=10U AS=2.1P AD=2.1P
+ PS=10.42U PD=10.42U
* device instance $839 r0 *1 266.21,648.04 nfet
M$839 GND_DRV x3_lockout OUT GND_LOGIC nfet L=0.7U W=10U AS=2.1P AD=2.1P
+ PS=10.42U PD=10.42U
* device instance $840 r0 *1 267.33,648.04 nfet
M$840 OUT x3_lockout GND_DRV GND_LOGIC nfet L=0.7U W=10U AS=2.1P AD=2.1P
+ PS=10.42U PD=10.42U
* device instance $841 r0 *1 268.45,648.04 nfet
M$841 GND_DRV x3_lockout OUT GND_LOGIC nfet L=0.7U W=10U AS=2.1P AD=2.1P
+ PS=10.42U PD=10.42U
* device instance $842 r0 *1 269.57,648.04 nfet
M$842 OUT x3_lockout GND_DRV GND_LOGIC nfet L=0.7U W=10U AS=2.1P AD=2.1P
+ PS=10.42U PD=10.42U
* device instance $843 r0 *1 270.69,648.04 nfet
M$843 GND_DRV x3_lockout OUT GND_LOGIC nfet L=0.7U W=10U AS=2.1P AD=2.1P
+ PS=10.42U PD=10.42U
* device instance $844 r0 *1 271.81,648.04 nfet
M$844 OUT x3_lockout GND_DRV GND_LOGIC nfet L=0.7U W=10U AS=2.1P AD=2.1P
+ PS=10.42U PD=10.42U
* device instance $845 r0 *1 272.93,648.04 nfet
M$845 GND_DRV x3_lockout OUT GND_LOGIC nfet L=0.7U W=10U AS=2.1P AD=2.1P
+ PS=10.42U PD=10.42U
* device instance $846 r0 *1 274.05,648.04 nfet
M$846 OUT x3_lockout GND_DRV GND_LOGIC nfet L=0.7U W=10U AS=2.1P AD=2.1P
+ PS=10.42U PD=10.42U
* device instance $847 r0 *1 275.17,648.04 nfet
M$847 GND_DRV x3_lockout OUT GND_LOGIC nfet L=0.7U W=10U AS=2.1P AD=2.1P
+ PS=10.42U PD=10.42U
* device instance $848 r0 *1 276.29,648.04 nfet
M$848 OUT x3_lockout GND_DRV GND_LOGIC nfet L=0.7U W=10U AS=2.1P AD=2.1P
+ PS=10.42U PD=10.42U
* device instance $849 r0 *1 277.41,648.04 nfet
M$849 GND_DRV x3_lockout OUT GND_LOGIC nfet L=0.7U W=10U AS=2.1P AD=2.1P
+ PS=10.42U PD=10.42U
* device instance $850 r0 *1 278.53,648.04 nfet
M$850 OUT x3_lockout GND_DRV GND_LOGIC nfet L=0.7U W=10U AS=2.1P AD=2.1P
+ PS=10.42U PD=10.42U
* device instance $851 r0 *1 279.65,648.04 nfet
M$851 GND_DRV x3_lockout OUT GND_LOGIC nfet L=0.7U W=10U AS=2.1P AD=2.1P
+ PS=10.42U PD=10.42U
* device instance $852 r0 *1 280.77,648.04 nfet
M$852 OUT x3_lockout GND_DRV GND_LOGIC nfet L=0.7U W=10U AS=2.1P AD=2.1P
+ PS=10.42U PD=10.42U
* device instance $853 r0 *1 281.89,648.04 nfet
M$853 GND_DRV x3_lockout OUT GND_LOGIC nfet L=0.7U W=10U AS=2.1P AD=2.1P
+ PS=10.42U PD=10.42U
* device instance $854 r0 *1 283.01,648.04 nfet
M$854 OUT x3_lockout GND_DRV GND_LOGIC nfet L=0.7U W=10U AS=2.1P AD=2.1P
+ PS=10.42U PD=10.42U
* device instance $855 r0 *1 284.13,648.04 nfet
M$855 GND_DRV x3_lockout OUT GND_LOGIC nfet L=0.7U W=10U AS=2.1P AD=2.1P
+ PS=10.42U PD=10.42U
* device instance $856 r0 *1 285.25,648.04 nfet
M$856 OUT x3_lockout GND_DRV GND_LOGIC nfet L=0.7U W=10U AS=2.1P AD=2.1P
+ PS=10.42U PD=10.42U
* device instance $857 r0 *1 286.37,648.04 nfet
M$857 GND_DRV x3_lockout OUT GND_LOGIC nfet L=0.7U W=10U AS=2.1P AD=2.1P
+ PS=10.42U PD=10.42U
* device instance $858 r0 *1 287.49,648.04 nfet
M$858 OUT x3_lockout GND_DRV GND_LOGIC nfet L=0.7U W=10U AS=2.1P AD=2.1P
+ PS=10.42U PD=10.42U
* device instance $859 r0 *1 288.61,648.04 nfet
M$859 GND_DRV x3_lockout OUT GND_LOGIC nfet L=0.7U W=10U AS=2.1P AD=2.1P
+ PS=10.42U PD=10.42U
* device instance $860 r0 *1 289.73,648.04 nfet
M$860 OUT x3_lockout GND_DRV GND_LOGIC nfet L=0.7U W=10U AS=2.1P AD=2.1P
+ PS=10.42U PD=10.42U
* device instance $861 r0 *1 290.85,648.04 nfet
M$861 GND_DRV x3_lockout OUT GND_LOGIC nfet L=0.7U W=10U AS=2.1P AD=2.1P
+ PS=10.42U PD=10.42U
* device instance $862 r0 *1 291.97,648.04 nfet
M$862 OUT x3_lockout GND_DRV GND_LOGIC nfet L=0.7U W=10U AS=2.1P AD=2.1P
+ PS=10.42U PD=10.42U
* device instance $863 r0 *1 293.09,648.04 nfet
M$863 GND_DRV x3_lockout OUT GND_LOGIC nfet L=0.7U W=10U AS=2.1P AD=2.1P
+ PS=10.42U PD=10.42U
* device instance $864 r0 *1 294.21,648.04 nfet
M$864 OUT x3_lockout GND_DRV GND_LOGIC nfet L=0.7U W=10U AS=2.1P AD=2.1P
+ PS=10.42U PD=10.42U
* device instance $865 r0 *1 295.33,648.04 nfet
M$865 GND_DRV x3_lockout OUT GND_LOGIC nfet L=0.7U W=10U AS=2.1P AD=2.1P
+ PS=10.42U PD=10.42U
* device instance $866 r0 *1 296.45,648.04 nfet
M$866 OUT x3_lockout GND_DRV GND_LOGIC nfet L=0.7U W=10U AS=2.1P AD=2.1P
+ PS=10.42U PD=10.42U
* device instance $867 r0 *1 297.57,648.04 nfet
M$867 GND_DRV x3_lockout OUT GND_LOGIC nfet L=0.7U W=10U AS=2.1P AD=2.1P
+ PS=10.42U PD=10.42U
* device instance $868 r0 *1 298.69,648.04 nfet
M$868 OUT x3_lockout GND_DRV GND_LOGIC nfet L=0.7U W=10U AS=2.1P AD=2.1P
+ PS=10.42U PD=10.42U
* device instance $869 r0 *1 299.81,648.04 nfet
M$869 GND_DRV x3_lockout OUT GND_LOGIC nfet L=0.7U W=10U AS=2.1P AD=2.1P
+ PS=10.42U PD=10.42U
* device instance $870 r0 *1 300.93,648.04 nfet
M$870 OUT x3_lockout GND_DRV GND_LOGIC nfet L=0.7U W=10U AS=2.1P AD=2.1P
+ PS=10.42U PD=10.42U
* device instance $871 r0 *1 302.05,648.04 nfet
M$871 GND_DRV x3_lockout OUT GND_LOGIC nfet L=0.7U W=10U AS=2.1P AD=2.1P
+ PS=10.42U PD=10.42U
* device instance $872 r0 *1 303.17,648.04 nfet
M$872 OUT x3_lockout GND_DRV GND_LOGIC nfet L=0.7U W=10U AS=2.1P AD=2.1P
+ PS=10.42U PD=10.42U
* device instance $873 r0 *1 304.29,648.04 nfet
M$873 GND_DRV x3_lockout OUT GND_LOGIC nfet L=0.7U W=10U AS=2.1P AD=2.1P
+ PS=10.42U PD=10.42U
* device instance $874 r0 *1 305.41,648.04 nfet
M$874 OUT x3_lockout GND_DRV GND_LOGIC nfet L=0.7U W=10U AS=2.1P AD=2.1P
+ PS=10.42U PD=10.42U
* device instance $875 r0 *1 306.53,648.04 nfet
M$875 GND_DRV x3_lockout OUT GND_LOGIC nfet L=0.7U W=10U AS=2.1P AD=2.1P
+ PS=10.42U PD=10.42U
* device instance $876 r0 *1 307.65,648.04 nfet
M$876 OUT x3_lockout GND_DRV GND_LOGIC nfet L=0.7U W=10U AS=2.1P AD=2.1P
+ PS=10.42U PD=10.42U
* device instance $877 r0 *1 308.77,648.04 nfet
M$877 GND_DRV x3_lockout OUT GND_LOGIC nfet L=0.7U W=10U AS=2.1P AD=2.1P
+ PS=10.42U PD=10.42U
* device instance $878 r0 *1 309.89,648.04 nfet
M$878 OUT x3_lockout GND_DRV GND_LOGIC nfet L=0.7U W=10U AS=2.1P AD=2.1P
+ PS=10.42U PD=10.42U
* device instance $879 r0 *1 311.01,648.04 nfet
M$879 GND_DRV x3_lockout OUT GND_LOGIC nfet L=0.7U W=10U AS=2.1P AD=2.1P
+ PS=10.42U PD=10.42U
* device instance $880 r0 *1 312.13,648.04 nfet
M$880 OUT x3_lockout GND_DRV GND_LOGIC nfet L=0.7U W=10U AS=2.1P AD=2.1P
+ PS=10.42U PD=10.42U
* device instance $881 r0 *1 313.25,648.04 nfet
M$881 GND_DRV x3_lockout OUT GND_LOGIC nfet L=0.7U W=10U AS=2.1P AD=2.1P
+ PS=10.42U PD=10.42U
* device instance $882 r0 *1 314.37,648.04 nfet
M$882 OUT x3_lockout GND_DRV GND_LOGIC nfet L=0.7U W=10U AS=2.1P AD=2.1P
+ PS=10.42U PD=10.42U
* device instance $883 r0 *1 315.49,648.04 nfet
M$883 GND_DRV x3_lockout OUT GND_LOGIC nfet L=0.7U W=10U AS=2.1P AD=2.1P
+ PS=10.42U PD=10.42U
* device instance $884 r0 *1 316.61,648.04 nfet
M$884 OUT x3_lockout GND_DRV GND_LOGIC nfet L=0.7U W=10U AS=2.1P AD=2.1P
+ PS=10.42U PD=10.42U
* device instance $885 r0 *1 317.73,648.04 nfet
M$885 GND_DRV x3_lockout OUT GND_LOGIC nfet L=0.7U W=10U AS=2.1P AD=2.1P
+ PS=10.42U PD=10.42U
* device instance $886 r0 *1 318.85,648.04 nfet
M$886 OUT x3_lockout GND_DRV GND_LOGIC nfet L=0.7U W=10U AS=2.1P AD=2.1P
+ PS=10.42U PD=10.42U
* device instance $887 r0 *1 319.97,648.04 nfet
M$887 GND_DRV x3_lockout OUT GND_LOGIC nfet L=0.7U W=10U AS=2.1P AD=2.1P
+ PS=10.42U PD=10.42U
* device instance $888 r0 *1 321.09,648.04 nfet
M$888 OUT x3_lockout GND_DRV GND_LOGIC nfet L=0.7U W=10U AS=2.1P AD=2.1P
+ PS=10.42U PD=10.42U
* device instance $889 r0 *1 322.21,648.04 nfet
M$889 GND_DRV x3_lockout OUT GND_LOGIC nfet L=0.7U W=10U AS=2.1P AD=2.1P
+ PS=10.42U PD=10.42U
* device instance $890 r0 *1 323.33,648.04 nfet
M$890 OUT x3_lockout GND_DRV GND_LOGIC nfet L=0.7U W=10U AS=2.1P AD=2.1P
+ PS=10.42U PD=10.42U
* device instance $891 r0 *1 324.45,648.04 nfet
M$891 GND_DRV x3_lockout OUT GND_LOGIC nfet L=0.7U W=10U AS=2.1P AD=2.1P
+ PS=10.42U PD=10.42U
* device instance $892 r0 *1 325.57,648.04 nfet
M$892 OUT x3_lockout GND_DRV GND_LOGIC nfet L=0.7U W=10U AS=2.1P AD=2.1P
+ PS=10.42U PD=10.42U
* device instance $893 r0 *1 326.69,648.04 nfet
M$893 GND_DRV x3_lockout OUT GND_LOGIC nfet L=0.7U W=10U AS=2.1P AD=2.1P
+ PS=10.42U PD=10.42U
* device instance $894 r0 *1 327.81,648.04 nfet
M$894 OUT x3_lockout GND_DRV GND_LOGIC nfet L=0.7U W=10U AS=2.1P AD=2.1P
+ PS=10.42U PD=10.42U
* device instance $895 r0 *1 328.93,648.04 nfet
M$895 GND_DRV x3_lockout OUT GND_LOGIC nfet L=0.7U W=10U AS=2.1P AD=2.1P
+ PS=10.42U PD=10.42U
* device instance $896 r0 *1 330.05,648.04 nfet
M$896 OUT x3_lockout GND_DRV GND_LOGIC nfet L=0.7U W=10U AS=2.1P AD=2.1P
+ PS=10.42U PD=10.42U
* device instance $897 r0 *1 331.17,648.04 nfet
M$897 GND_DRV x3_lockout OUT GND_LOGIC nfet L=0.7U W=10U AS=2.1P AD=2.1P
+ PS=10.42U PD=10.42U
* device instance $898 r0 *1 332.29,648.04 nfet
M$898 OUT x3_lockout GND_DRV GND_LOGIC nfet L=0.7U W=10U AS=2.1P AD=2.1P
+ PS=10.42U PD=10.42U
* device instance $899 r0 *1 333.41,648.04 nfet
M$899 GND_DRV x3_lockout OUT GND_LOGIC nfet L=0.7U W=10U AS=2.1P AD=2.1P
+ PS=10.42U PD=10.42U
* device instance $900 r0 *1 334.53,648.04 nfet
M$900 OUT x3_lockout GND_DRV GND_LOGIC nfet L=0.7U W=10U AS=2.1P AD=2.1P
+ PS=10.42U PD=10.42U
* device instance $901 r0 *1 335.65,648.04 nfet
M$901 GND_DRV x3_lockout OUT GND_LOGIC nfet L=0.7U W=10U AS=2.1P AD=2.1P
+ PS=10.42U PD=10.42U
* device instance $902 r0 *1 112.77,648.04 nfet
M$902 OUT x3_lockout GND_DRV GND_LOGIC nfet L=0.7U W=10U AS=2.1P AD=2.1P
+ PS=10.42U PD=10.42U
* device instance $903 r0 *1 113.89,648.04 nfet
M$903 GND_DRV x3_lockout OUT GND_LOGIC nfet L=0.7U W=10U AS=2.1P AD=2.1P
+ PS=10.42U PD=10.42U
* device instance $904 r0 *1 115.01,648.04 nfet
M$904 OUT x3_lockout GND_DRV GND_LOGIC nfet L=0.7U W=10U AS=2.1P AD=2.1P
+ PS=10.42U PD=10.42U
* device instance $905 r0 *1 116.13,648.04 nfet
M$905 GND_DRV x3_lockout OUT GND_LOGIC nfet L=0.7U W=10U AS=2.1P AD=2.1P
+ PS=10.42U PD=10.42U
* device instance $906 r0 *1 117.25,648.04 nfet
M$906 OUT x3_lockout GND_DRV GND_LOGIC nfet L=0.7U W=10U AS=2.1P AD=2.1P
+ PS=10.42U PD=10.42U
* device instance $907 r0 *1 118.37,648.04 nfet
M$907 GND_DRV x3_lockout OUT GND_LOGIC nfet L=0.7U W=10U AS=2.1P AD=2.1P
+ PS=10.42U PD=10.42U
* device instance $908 r0 *1 119.49,648.04 nfet
M$908 OUT x3_lockout GND_DRV GND_LOGIC nfet L=0.7U W=10U AS=2.1P AD=2.1P
+ PS=10.42U PD=10.42U
* device instance $909 r0 *1 120.61,648.04 nfet
M$909 GND_DRV x3_lockout OUT GND_LOGIC nfet L=0.7U W=10U AS=2.1P AD=2.1P
+ PS=10.42U PD=10.42U
* device instance $910 r0 *1 121.73,648.04 nfet
M$910 OUT x3_lockout GND_DRV GND_LOGIC nfet L=0.7U W=10U AS=2.1P AD=2.1P
+ PS=10.42U PD=10.42U
* device instance $911 r0 *1 122.85,648.04 nfet
M$911 GND_DRV x3_lockout OUT GND_LOGIC nfet L=0.7U W=10U AS=2.1P AD=2.1P
+ PS=10.42U PD=10.42U
* device instance $912 r0 *1 123.97,648.04 nfet
M$912 OUT x3_lockout GND_DRV GND_LOGIC nfet L=0.7U W=10U AS=2.1P AD=2.1P
+ PS=10.42U PD=10.42U
* device instance $913 r0 *1 125.09,648.04 nfet
M$913 GND_DRV x3_lockout OUT GND_LOGIC nfet L=0.7U W=10U AS=2.1P AD=2.1P
+ PS=10.42U PD=10.42U
* device instance $914 r0 *1 126.21,648.04 nfet
M$914 OUT x3_lockout GND_DRV GND_LOGIC nfet L=0.7U W=10U AS=2.1P AD=2.1P
+ PS=10.42U PD=10.42U
* device instance $915 r0 *1 127.33,648.04 nfet
M$915 GND_DRV x3_lockout OUT GND_LOGIC nfet L=0.7U W=10U AS=2.1P AD=2.1P
+ PS=10.42U PD=10.42U
* device instance $916 r0 *1 128.45,648.04 nfet
M$916 OUT x3_lockout GND_DRV GND_LOGIC nfet L=0.7U W=10U AS=2.1P AD=2.1P
+ PS=10.42U PD=10.42U
* device instance $917 r0 *1 129.57,648.04 nfet
M$917 GND_DRV x3_lockout OUT GND_LOGIC nfet L=0.7U W=10U AS=2.1P AD=2.1P
+ PS=10.42U PD=10.42U
* device instance $918 r0 *1 130.69,648.04 nfet
M$918 OUT x3_lockout GND_DRV GND_LOGIC nfet L=0.7U W=10U AS=2.1P AD=2.1P
+ PS=10.42U PD=10.42U
* device instance $919 r0 *1 131.81,648.04 nfet
M$919 GND_DRV x3_lockout OUT GND_LOGIC nfet L=0.7U W=10U AS=2.1P AD=2.1P
+ PS=10.42U PD=10.42U
* device instance $920 r0 *1 132.93,648.04 nfet
M$920 OUT x3_lockout GND_DRV GND_LOGIC nfet L=0.7U W=10U AS=2.1P AD=2.1P
+ PS=10.42U PD=10.42U
* device instance $921 r0 *1 134.05,648.04 nfet
M$921 GND_DRV x3_lockout OUT GND_LOGIC nfet L=0.7U W=10U AS=2.1P AD=2.1P
+ PS=10.42U PD=10.42U
* device instance $922 r0 *1 135.17,648.04 nfet
M$922 OUT x3_lockout GND_DRV GND_LOGIC nfet L=0.7U W=10U AS=2.1P AD=2.1P
+ PS=10.42U PD=10.42U
* device instance $923 r0 *1 136.29,648.04 nfet
M$923 GND_DRV x3_lockout OUT GND_LOGIC nfet L=0.7U W=10U AS=2.1P AD=2.1P
+ PS=10.42U PD=10.42U
* device instance $924 r0 *1 137.41,648.04 nfet
M$924 OUT x3_lockout GND_DRV GND_LOGIC nfet L=0.7U W=10U AS=2.1P AD=2.1P
+ PS=10.42U PD=10.42U
* device instance $925 r0 *1 138.53,648.04 nfet
M$925 GND_DRV x3_lockout OUT GND_LOGIC nfet L=0.7U W=10U AS=2.1P AD=2.1P
+ PS=10.42U PD=10.42U
* device instance $926 r0 *1 139.65,648.04 nfet
M$926 OUT x3_lockout GND_DRV GND_LOGIC nfet L=0.7U W=10U AS=2.1P AD=2.1P
+ PS=10.42U PD=10.42U
* device instance $927 r0 *1 140.77,648.04 nfet
M$927 GND_DRV x3_lockout OUT GND_LOGIC nfet L=0.7U W=10U AS=2.1P AD=2.1P
+ PS=10.42U PD=10.42U
* device instance $928 r0 *1 141.89,648.04 nfet
M$928 OUT x3_lockout GND_DRV GND_LOGIC nfet L=0.7U W=10U AS=2.1P AD=2.1P
+ PS=10.42U PD=10.42U
* device instance $929 r0 *1 143.01,648.04 nfet
M$929 GND_DRV x3_lockout OUT GND_LOGIC nfet L=0.7U W=10U AS=2.1P AD=2.1P
+ PS=10.42U PD=10.42U
* device instance $930 r0 *1 144.13,648.04 nfet
M$930 OUT x3_lockout GND_DRV GND_LOGIC nfet L=0.7U W=10U AS=2.1P AD=2.1P
+ PS=10.42U PD=10.42U
* device instance $931 r0 *1 145.25,648.04 nfet
M$931 GND_DRV x3_lockout OUT GND_LOGIC nfet L=0.7U W=10U AS=2.1P AD=2.1P
+ PS=10.42U PD=10.42U
* device instance $932 r0 *1 146.37,648.04 nfet
M$932 OUT x3_lockout GND_DRV GND_LOGIC nfet L=0.7U W=10U AS=2.1P AD=2.1P
+ PS=10.42U PD=10.42U
* device instance $933 r0 *1 147.49,648.04 nfet
M$933 GND_DRV x3_lockout OUT GND_LOGIC nfet L=0.7U W=10U AS=2.1P AD=2.1P
+ PS=10.42U PD=10.42U
* device instance $934 r0 *1 148.61,648.04 nfet
M$934 OUT x3_lockout GND_DRV GND_LOGIC nfet L=0.7U W=10U AS=2.1P AD=2.1P
+ PS=10.42U PD=10.42U
* device instance $935 r0 *1 149.73,648.04 nfet
M$935 GND_DRV x3_lockout OUT GND_LOGIC nfet L=0.7U W=10U AS=2.1P AD=2.1P
+ PS=10.42U PD=10.42U
* device instance $936 r0 *1 150.85,648.04 nfet
M$936 OUT x3_lockout GND_DRV GND_LOGIC nfet L=0.7U W=10U AS=2.1P AD=2.1P
+ PS=10.42U PD=10.42U
* device instance $937 r0 *1 151.97,648.04 nfet
M$937 GND_DRV x3_lockout OUT GND_LOGIC nfet L=0.7U W=10U AS=2.1P AD=2.1P
+ PS=10.42U PD=10.42U
* device instance $938 r0 *1 153.09,648.04 nfet
M$938 OUT x3_lockout GND_DRV GND_LOGIC nfet L=0.7U W=10U AS=2.1P AD=2.1P
+ PS=10.42U PD=10.42U
* device instance $939 r0 *1 154.21,648.04 nfet
M$939 GND_DRV x3_lockout OUT GND_LOGIC nfet L=0.7U W=10U AS=2.1P AD=2.1P
+ PS=10.42U PD=10.42U
* device instance $940 r0 *1 155.33,648.04 nfet
M$940 OUT x3_lockout GND_DRV GND_LOGIC nfet L=0.7U W=10U AS=2.1P AD=2.1P
+ PS=10.42U PD=10.42U
* device instance $941 r0 *1 156.45,648.04 nfet
M$941 GND_DRV x3_lockout OUT GND_LOGIC nfet L=0.7U W=10U AS=2.1P AD=2.1P
+ PS=10.42U PD=10.42U
* device instance $942 r0 *1 157.57,648.04 nfet
M$942 OUT x3_lockout GND_DRV GND_LOGIC nfet L=0.7U W=10U AS=2.1P AD=2.1P
+ PS=10.42U PD=10.42U
* device instance $943 r0 *1 158.69,648.04 nfet
M$943 GND_DRV x3_lockout OUT GND_LOGIC nfet L=0.7U W=10U AS=2.1P AD=2.1P
+ PS=10.42U PD=10.42U
* device instance $944 r0 *1 159.81,648.04 nfet
M$944 OUT x3_lockout GND_DRV GND_LOGIC nfet L=0.7U W=10U AS=2.1P AD=2.1P
+ PS=10.42U PD=10.42U
* device instance $945 r0 *1 160.93,648.04 nfet
M$945 GND_DRV x3_lockout OUT GND_LOGIC nfet L=0.7U W=10U AS=2.1P AD=2.1P
+ PS=10.42U PD=10.42U
* device instance $946 r0 *1 162.05,648.04 nfet
M$946 OUT x3_lockout GND_DRV GND_LOGIC nfet L=0.7U W=10U AS=2.1P AD=2.1P
+ PS=10.42U PD=10.42U
* device instance $947 r0 *1 163.17,648.04 nfet
M$947 GND_DRV x3_lockout OUT GND_LOGIC nfet L=0.7U W=10U AS=2.1P AD=2.1P
+ PS=10.42U PD=10.42U
* device instance $948 r0 *1 164.29,648.04 nfet
M$948 OUT x3_lockout GND_DRV GND_LOGIC nfet L=0.7U W=10U AS=2.1P AD=2.1P
+ PS=10.42U PD=10.42U
* device instance $949 r0 *1 165.41,648.04 nfet
M$949 GND_DRV x3_lockout OUT GND_LOGIC nfet L=0.7U W=10U AS=2.1P AD=2.1P
+ PS=10.42U PD=10.42U
* device instance $950 r0 *1 166.53,648.04 nfet
M$950 OUT x3_lockout GND_DRV GND_LOGIC nfet L=0.7U W=10U AS=2.1P AD=2.1P
+ PS=10.42U PD=10.42U
* device instance $951 r0 *1 167.65,648.04 nfet
M$951 GND_DRV x3_lockout OUT GND_LOGIC nfet L=0.7U W=10U AS=2.1P AD=2.1P
+ PS=10.42U PD=10.42U
* device instance $952 r0 *1 168.77,648.04 nfet
M$952 OUT x3_lockout GND_DRV GND_LOGIC nfet L=0.7U W=10U AS=2.1P AD=2.1P
+ PS=10.42U PD=10.42U
* device instance $953 r0 *1 169.89,648.04 nfet
M$953 GND_DRV x3_lockout OUT GND_LOGIC nfet L=0.7U W=10U AS=2.1P AD=2.1P
+ PS=10.42U PD=10.42U
* device instance $954 r0 *1 171.01,648.04 nfet
M$954 OUT x3_lockout GND_DRV GND_LOGIC nfet L=0.7U W=10U AS=2.1P AD=2.1P
+ PS=10.42U PD=10.42U
* device instance $955 r0 *1 172.13,648.04 nfet
M$955 GND_DRV x3_lockout OUT GND_LOGIC nfet L=0.7U W=10U AS=2.1P AD=2.1P
+ PS=10.42U PD=10.42U
* device instance $956 r0 *1 173.25,648.04 nfet
M$956 OUT x3_lockout GND_DRV GND_LOGIC nfet L=0.7U W=10U AS=2.1P AD=2.1P
+ PS=10.42U PD=10.42U
* device instance $957 r0 *1 174.37,648.04 nfet
M$957 GND_DRV x3_lockout OUT GND_LOGIC nfet L=0.7U W=10U AS=2.1P AD=2.1P
+ PS=10.42U PD=10.42U
* device instance $958 r0 *1 175.49,648.04 nfet
M$958 OUT x3_lockout GND_DRV GND_LOGIC nfet L=0.7U W=10U AS=2.1P AD=2.1P
+ PS=10.42U PD=10.42U
* device instance $959 r0 *1 176.61,648.04 nfet
M$959 GND_DRV x3_lockout OUT GND_LOGIC nfet L=0.7U W=10U AS=2.1P AD=2.1P
+ PS=10.42U PD=10.42U
* device instance $960 r0 *1 177.73,648.04 nfet
M$960 OUT x3_lockout GND_DRV GND_LOGIC nfet L=0.7U W=10U AS=2.1P AD=2.1P
+ PS=10.42U PD=10.42U
* device instance $961 r0 *1 178.85,648.04 nfet
M$961 GND_DRV x3_lockout OUT GND_LOGIC nfet L=0.7U W=10U AS=2.1P AD=2.1P
+ PS=10.42U PD=10.42U
* device instance $962 r0 *1 179.97,648.04 nfet
M$962 OUT x3_lockout GND_DRV GND_LOGIC nfet L=0.7U W=10U AS=2.1P AD=2.1P
+ PS=10.42U PD=10.42U
* device instance $963 r0 *1 181.09,648.04 nfet
M$963 GND_DRV x3_lockout OUT GND_LOGIC nfet L=0.7U W=10U AS=2.1P AD=2.1P
+ PS=10.42U PD=10.42U
* device instance $964 r0 *1 182.21,648.04 nfet
M$964 OUT x3_lockout GND_DRV GND_LOGIC nfet L=0.7U W=10U AS=2.1P AD=2.1P
+ PS=10.42U PD=10.42U
* device instance $965 r0 *1 183.33,648.04 nfet
M$965 GND_DRV x3_lockout OUT GND_LOGIC nfet L=0.7U W=10U AS=2.1P AD=2.1P
+ PS=10.42U PD=10.42U
* device instance $966 r0 *1 184.45,648.04 nfet
M$966 OUT x3_lockout GND_DRV GND_LOGIC nfet L=0.7U W=10U AS=2.1P AD=2.1P
+ PS=10.42U PD=10.42U
* device instance $967 r0 *1 185.57,648.04 nfet
M$967 GND_DRV x3_lockout OUT GND_LOGIC nfet L=0.7U W=10U AS=2.1P AD=2.1P
+ PS=10.42U PD=10.42U
* device instance $968 r0 *1 186.69,648.04 nfet
M$968 OUT x3_lockout GND_DRV GND_LOGIC nfet L=0.7U W=10U AS=2.1P AD=2.1P
+ PS=10.42U PD=10.42U
* device instance $969 r0 *1 187.81,648.04 nfet
M$969 GND_DRV x3_lockout OUT GND_LOGIC nfet L=0.7U W=10U AS=2.1P AD=2.1P
+ PS=10.42U PD=10.42U
* device instance $970 r0 *1 188.93,648.04 nfet
M$970 OUT x3_lockout GND_DRV GND_LOGIC nfet L=0.7U W=10U AS=2.1P AD=2.1P
+ PS=10.42U PD=10.42U
* device instance $971 r0 *1 190.05,648.04 nfet
M$971 GND_DRV x3_lockout OUT GND_LOGIC nfet L=0.7U W=10U AS=2.1P AD=2.1P
+ PS=10.42U PD=10.42U
* device instance $972 r0 *1 191.17,648.04 nfet
M$972 OUT x3_lockout GND_DRV GND_LOGIC nfet L=0.7U W=10U AS=2.1P AD=2.1P
+ PS=10.42U PD=10.42U
* device instance $973 r0 *1 192.29,648.04 nfet
M$973 GND_DRV x3_lockout OUT GND_LOGIC nfet L=0.7U W=10U AS=2.1P AD=2.1P
+ PS=10.42U PD=10.42U
* device instance $974 r0 *1 193.41,648.04 nfet
M$974 OUT x3_lockout GND_DRV GND_LOGIC nfet L=0.7U W=10U AS=2.1P AD=2.1P
+ PS=10.42U PD=10.42U
* device instance $975 r0 *1 194.53,648.04 nfet
M$975 GND_DRV x3_lockout OUT GND_LOGIC nfet L=0.7U W=10U AS=2.1P AD=2.1P
+ PS=10.42U PD=10.42U
* device instance $976 r0 *1 195.65,648.04 nfet
M$976 OUT x3_lockout GND_DRV GND_LOGIC nfet L=0.7U W=10U AS=2.1P AD=2.1P
+ PS=10.42U PD=10.42U
* device instance $977 r0 *1 196.77,648.04 nfet
M$977 GND_DRV x3_lockout OUT GND_LOGIC nfet L=0.7U W=10U AS=2.1P AD=2.1P
+ PS=10.42U PD=10.42U
* device instance $978 r0 *1 197.89,648.04 nfet
M$978 OUT x3_lockout GND_DRV GND_LOGIC nfet L=0.7U W=10U AS=2.1P AD=2.1P
+ PS=10.42U PD=10.42U
* device instance $979 r0 *1 199.01,648.04 nfet
M$979 GND_DRV x3_lockout OUT GND_LOGIC nfet L=0.7U W=10U AS=2.1P AD=2.1P
+ PS=10.42U PD=10.42U
* device instance $980 r0 *1 200.13,648.04 nfet
M$980 OUT x3_lockout GND_DRV GND_LOGIC nfet L=0.7U W=10U AS=2.1P AD=2.1P
+ PS=10.42U PD=10.42U
* device instance $981 r0 *1 201.25,648.04 nfet
M$981 GND_DRV x3_lockout OUT GND_LOGIC nfet L=0.7U W=10U AS=2.1P AD=2.1P
+ PS=10.42U PD=10.42U
* device instance $982 r0 *1 202.37,648.04 nfet
M$982 OUT x3_lockout GND_DRV GND_LOGIC nfet L=0.7U W=10U AS=2.1P AD=2.1P
+ PS=10.42U PD=10.42U
* device instance $983 r0 *1 203.49,648.04 nfet
M$983 GND_DRV x3_lockout OUT GND_LOGIC nfet L=0.7U W=10U AS=2.1P AD=2.1P
+ PS=10.42U PD=10.42U
* device instance $984 r0 *1 204.61,648.04 nfet
M$984 OUT x3_lockout GND_DRV GND_LOGIC nfet L=0.7U W=10U AS=2.1P AD=2.1P
+ PS=10.42U PD=10.42U
* device instance $985 r0 *1 205.73,648.04 nfet
M$985 GND_DRV x3_lockout OUT GND_LOGIC nfet L=0.7U W=10U AS=2.1P AD=2.1P
+ PS=10.42U PD=10.42U
* device instance $986 r0 *1 206.85,648.04 nfet
M$986 OUT x3_lockout GND_DRV GND_LOGIC nfet L=0.7U W=10U AS=2.1P AD=2.1P
+ PS=10.42U PD=10.42U
* device instance $987 r0 *1 207.97,648.04 nfet
M$987 GND_DRV x3_lockout OUT GND_LOGIC nfet L=0.7U W=10U AS=2.1P AD=2.1P
+ PS=10.42U PD=10.42U
* device instance $988 r0 *1 209.09,648.04 nfet
M$988 OUT x3_lockout GND_DRV GND_LOGIC nfet L=0.7U W=10U AS=2.1P AD=2.1P
+ PS=10.42U PD=10.42U
* device instance $989 r0 *1 210.21,648.04 nfet
M$989 GND_DRV x3_lockout OUT GND_LOGIC nfet L=0.7U W=10U AS=2.1P AD=2.1P
+ PS=10.42U PD=10.42U
* device instance $990 r0 *1 211.33,648.04 nfet
M$990 OUT x3_lockout GND_DRV GND_LOGIC nfet L=0.7U W=10U AS=2.1P AD=2.1P
+ PS=10.42U PD=10.42U
* device instance $991 r0 *1 212.45,648.04 nfet
M$991 GND_DRV x3_lockout OUT GND_LOGIC nfet L=0.7U W=10U AS=2.1P AD=2.1P
+ PS=10.42U PD=10.42U
* device instance $992 r0 *1 213.57,648.04 nfet
M$992 OUT x3_lockout GND_DRV GND_LOGIC nfet L=0.7U W=10U AS=2.1P AD=2.1P
+ PS=10.42U PD=10.42U
* device instance $993 r0 *1 214.69,648.04 nfet
M$993 GND_DRV x3_lockout OUT GND_LOGIC nfet L=0.7U W=10U AS=2.1P AD=2.1P
+ PS=10.42U PD=10.42U
* device instance $994 r0 *1 215.81,648.04 nfet
M$994 OUT x3_lockout GND_DRV GND_LOGIC nfet L=0.7U W=10U AS=2.1P AD=2.1P
+ PS=10.42U PD=10.42U
* device instance $995 r0 *1 216.93,648.04 nfet
M$995 GND_DRV x3_lockout OUT GND_LOGIC nfet L=0.7U W=10U AS=2.1P AD=2.1P
+ PS=10.42U PD=10.42U
* device instance $996 r0 *1 218.05,648.04 nfet
M$996 OUT x3_lockout GND_DRV GND_LOGIC nfet L=0.7U W=10U AS=2.1P AD=2.1P
+ PS=10.42U PD=10.42U
* device instance $997 r0 *1 219.17,648.04 nfet
M$997 GND_DRV x3_lockout OUT GND_LOGIC nfet L=0.7U W=10U AS=2.1P AD=2.1P
+ PS=10.42U PD=10.42U
* device instance $998 r0 *1 220.29,648.04 nfet
M$998 OUT x3_lockout GND_DRV GND_LOGIC nfet L=0.7U W=10U AS=2.1P AD=2.1P
+ PS=10.42U PD=10.42U
* device instance $999 r0 *1 221.41,648.04 nfet
M$999 GND_DRV x3_lockout OUT GND_LOGIC nfet L=0.7U W=10U AS=2.1P AD=2.1P
+ PS=10.42U PD=10.42U
* device instance $1000 r0 *1 222.53,648.04 nfet
M$1000 OUT x3_lockout GND_DRV GND_LOGIC nfet L=0.7U W=10U AS=2.1P AD=2.1P
+ PS=10.42U PD=10.42U
* device instance $1001 r0 *1 223.65,648.04 nfet
M$1001 GND_DRV x3_lockout OUT GND_LOGIC nfet L=0.7U W=10U AS=2.1P AD=2.1P
+ PS=10.42U PD=10.42U
* device instance $1002 r0 *1 0.77,648.04 nfet
M$1002 OUT x3_lockout GND_DRV GND_LOGIC nfet L=0.7U W=10U AS=4.2P AD=2.1P
+ PS=20.84U PD=10.42U
* device instance $1003 r0 *1 1.89,648.04 nfet
M$1003 GND_DRV x3_lockout OUT GND_LOGIC nfet L=0.7U W=10U AS=2.1P AD=2.1P
+ PS=10.42U PD=10.42U
* device instance $1004 r0 *1 3.01,648.04 nfet
M$1004 OUT x3_lockout GND_DRV GND_LOGIC nfet L=0.7U W=10U AS=2.1P AD=2.1P
+ PS=10.42U PD=10.42U
* device instance $1005 r0 *1 4.13,648.04 nfet
M$1005 GND_DRV x3_lockout OUT GND_LOGIC nfet L=0.7U W=10U AS=2.1P AD=2.1P
+ PS=10.42U PD=10.42U
* device instance $1006 r0 *1 5.25,648.04 nfet
M$1006 OUT x3_lockout GND_DRV GND_LOGIC nfet L=0.7U W=10U AS=2.1P AD=2.1P
+ PS=10.42U PD=10.42U
* device instance $1007 r0 *1 6.37,648.04 nfet
M$1007 GND_DRV x3_lockout OUT GND_LOGIC nfet L=0.7U W=10U AS=2.1P AD=2.1P
+ PS=10.42U PD=10.42U
* device instance $1008 r0 *1 7.49,648.04 nfet
M$1008 OUT x3_lockout GND_DRV GND_LOGIC nfet L=0.7U W=10U AS=2.1P AD=2.1P
+ PS=10.42U PD=10.42U
* device instance $1009 r0 *1 8.61,648.04 nfet
M$1009 GND_DRV x3_lockout OUT GND_LOGIC nfet L=0.7U W=10U AS=2.1P AD=2.1P
+ PS=10.42U PD=10.42U
* device instance $1010 r0 *1 9.73,648.04 nfet
M$1010 OUT x3_lockout GND_DRV GND_LOGIC nfet L=0.7U W=10U AS=2.1P AD=2.1P
+ PS=10.42U PD=10.42U
* device instance $1011 r0 *1 10.85,648.04 nfet
M$1011 GND_DRV x3_lockout OUT GND_LOGIC nfet L=0.7U W=10U AS=2.1P AD=2.1P
+ PS=10.42U PD=10.42U
* device instance $1012 r0 *1 11.97,648.04 nfet
M$1012 OUT x3_lockout GND_DRV GND_LOGIC nfet L=0.7U W=10U AS=2.1P AD=2.1P
+ PS=10.42U PD=10.42U
* device instance $1013 r0 *1 13.09,648.04 nfet
M$1013 GND_DRV x3_lockout OUT GND_LOGIC nfet L=0.7U W=10U AS=2.1P AD=2.1P
+ PS=10.42U PD=10.42U
* device instance $1014 r0 *1 14.21,648.04 nfet
M$1014 OUT x3_lockout GND_DRV GND_LOGIC nfet L=0.7U W=10U AS=2.1P AD=2.1P
+ PS=10.42U PD=10.42U
* device instance $1015 r0 *1 15.33,648.04 nfet
M$1015 GND_DRV x3_lockout OUT GND_LOGIC nfet L=0.7U W=10U AS=2.1P AD=2.1P
+ PS=10.42U PD=10.42U
* device instance $1016 r0 *1 16.45,648.04 nfet
M$1016 OUT x3_lockout GND_DRV GND_LOGIC nfet L=0.7U W=10U AS=2.1P AD=2.1P
+ PS=10.42U PD=10.42U
* device instance $1017 r0 *1 17.57,648.04 nfet
M$1017 GND_DRV x3_lockout OUT GND_LOGIC nfet L=0.7U W=10U AS=2.1P AD=2.1P
+ PS=10.42U PD=10.42U
* device instance $1018 r0 *1 18.69,648.04 nfet
M$1018 OUT x3_lockout GND_DRV GND_LOGIC nfet L=0.7U W=10U AS=2.1P AD=2.1P
+ PS=10.42U PD=10.42U
* device instance $1019 r0 *1 19.81,648.04 nfet
M$1019 GND_DRV x3_lockout OUT GND_LOGIC nfet L=0.7U W=10U AS=2.1P AD=2.1P
+ PS=10.42U PD=10.42U
* device instance $1020 r0 *1 20.93,648.04 nfet
M$1020 OUT x3_lockout GND_DRV GND_LOGIC nfet L=0.7U W=10U AS=2.1P AD=2.1P
+ PS=10.42U PD=10.42U
* device instance $1021 r0 *1 22.05,648.04 nfet
M$1021 GND_DRV x3_lockout OUT GND_LOGIC nfet L=0.7U W=10U AS=2.1P AD=2.1P
+ PS=10.42U PD=10.42U
* device instance $1022 r0 *1 23.17,648.04 nfet
M$1022 OUT x3_lockout GND_DRV GND_LOGIC nfet L=0.7U W=10U AS=2.1P AD=2.1P
+ PS=10.42U PD=10.42U
* device instance $1023 r0 *1 24.29,648.04 nfet
M$1023 GND_DRV x3_lockout OUT GND_LOGIC nfet L=0.7U W=10U AS=2.1P AD=2.1P
+ PS=10.42U PD=10.42U
* device instance $1024 r0 *1 25.41,648.04 nfet
M$1024 OUT x3_lockout GND_DRV GND_LOGIC nfet L=0.7U W=10U AS=2.1P AD=2.1P
+ PS=10.42U PD=10.42U
* device instance $1025 r0 *1 26.53,648.04 nfet
M$1025 GND_DRV x3_lockout OUT GND_LOGIC nfet L=0.7U W=10U AS=2.1P AD=2.1P
+ PS=10.42U PD=10.42U
* device instance $1026 r0 *1 27.65,648.04 nfet
M$1026 OUT x3_lockout GND_DRV GND_LOGIC nfet L=0.7U W=10U AS=2.1P AD=2.1P
+ PS=10.42U PD=10.42U
* device instance $1027 r0 *1 28.77,648.04 nfet
M$1027 GND_DRV x3_lockout OUT GND_LOGIC nfet L=0.7U W=10U AS=2.1P AD=2.1P
+ PS=10.42U PD=10.42U
* device instance $1028 r0 *1 29.89,648.04 nfet
M$1028 OUT x3_lockout GND_DRV GND_LOGIC nfet L=0.7U W=10U AS=2.1P AD=2.1P
+ PS=10.42U PD=10.42U
* device instance $1029 r0 *1 31.01,648.04 nfet
M$1029 GND_DRV x3_lockout OUT GND_LOGIC nfet L=0.7U W=10U AS=2.1P AD=2.1P
+ PS=10.42U PD=10.42U
* device instance $1030 r0 *1 32.13,648.04 nfet
M$1030 OUT x3_lockout GND_DRV GND_LOGIC nfet L=0.7U W=10U AS=2.1P AD=2.1P
+ PS=10.42U PD=10.42U
* device instance $1031 r0 *1 33.25,648.04 nfet
M$1031 GND_DRV x3_lockout OUT GND_LOGIC nfet L=0.7U W=10U AS=2.1P AD=2.1P
+ PS=10.42U PD=10.42U
* device instance $1032 r0 *1 34.37,648.04 nfet
M$1032 OUT x3_lockout GND_DRV GND_LOGIC nfet L=0.7U W=10U AS=2.1P AD=2.1P
+ PS=10.42U PD=10.42U
* device instance $1033 r0 *1 35.49,648.04 nfet
M$1033 GND_DRV x3_lockout OUT GND_LOGIC nfet L=0.7U W=10U AS=2.1P AD=2.1P
+ PS=10.42U PD=10.42U
* device instance $1034 r0 *1 36.61,648.04 nfet
M$1034 OUT x3_lockout GND_DRV GND_LOGIC nfet L=0.7U W=10U AS=2.1P AD=2.1P
+ PS=10.42U PD=10.42U
* device instance $1035 r0 *1 37.73,648.04 nfet
M$1035 GND_DRV x3_lockout OUT GND_LOGIC nfet L=0.7U W=10U AS=2.1P AD=2.1P
+ PS=10.42U PD=10.42U
* device instance $1036 r0 *1 38.85,648.04 nfet
M$1036 OUT x3_lockout GND_DRV GND_LOGIC nfet L=0.7U W=10U AS=2.1P AD=2.1P
+ PS=10.42U PD=10.42U
* device instance $1037 r0 *1 39.97,648.04 nfet
M$1037 GND_DRV x3_lockout OUT GND_LOGIC nfet L=0.7U W=10U AS=2.1P AD=2.1P
+ PS=10.42U PD=10.42U
* device instance $1038 r0 *1 41.09,648.04 nfet
M$1038 OUT x3_lockout GND_DRV GND_LOGIC nfet L=0.7U W=10U AS=2.1P AD=2.1P
+ PS=10.42U PD=10.42U
* device instance $1039 r0 *1 42.21,648.04 nfet
M$1039 GND_DRV x3_lockout OUT GND_LOGIC nfet L=0.7U W=10U AS=2.1P AD=2.1P
+ PS=10.42U PD=10.42U
* device instance $1040 r0 *1 43.33,648.04 nfet
M$1040 OUT x3_lockout GND_DRV GND_LOGIC nfet L=0.7U W=10U AS=2.1P AD=2.1P
+ PS=10.42U PD=10.42U
* device instance $1041 r0 *1 44.45,648.04 nfet
M$1041 GND_DRV x3_lockout OUT GND_LOGIC nfet L=0.7U W=10U AS=2.1P AD=2.1P
+ PS=10.42U PD=10.42U
* device instance $1042 r0 *1 45.57,648.04 nfet
M$1042 OUT x3_lockout GND_DRV GND_LOGIC nfet L=0.7U W=10U AS=2.1P AD=2.1P
+ PS=10.42U PD=10.42U
* device instance $1043 r0 *1 46.69,648.04 nfet
M$1043 GND_DRV x3_lockout OUT GND_LOGIC nfet L=0.7U W=10U AS=2.1P AD=2.1P
+ PS=10.42U PD=10.42U
* device instance $1044 r0 *1 47.81,648.04 nfet
M$1044 OUT x3_lockout GND_DRV GND_LOGIC nfet L=0.7U W=10U AS=2.1P AD=2.1P
+ PS=10.42U PD=10.42U
* device instance $1045 r0 *1 48.93,648.04 nfet
M$1045 GND_DRV x3_lockout OUT GND_LOGIC nfet L=0.7U W=10U AS=2.1P AD=2.1P
+ PS=10.42U PD=10.42U
* device instance $1046 r0 *1 50.05,648.04 nfet
M$1046 OUT x3_lockout GND_DRV GND_LOGIC nfet L=0.7U W=10U AS=2.1P AD=2.1P
+ PS=10.42U PD=10.42U
* device instance $1047 r0 *1 51.17,648.04 nfet
M$1047 GND_DRV x3_lockout OUT GND_LOGIC nfet L=0.7U W=10U AS=2.1P AD=2.1P
+ PS=10.42U PD=10.42U
* device instance $1048 r0 *1 52.29,648.04 nfet
M$1048 OUT x3_lockout GND_DRV GND_LOGIC nfet L=0.7U W=10U AS=2.1P AD=2.1P
+ PS=10.42U PD=10.42U
* device instance $1049 r0 *1 53.41,648.04 nfet
M$1049 GND_DRV x3_lockout OUT GND_LOGIC nfet L=0.7U W=10U AS=2.1P AD=2.1P
+ PS=10.42U PD=10.42U
* device instance $1050 r0 *1 54.53,648.04 nfet
M$1050 OUT x3_lockout GND_DRV GND_LOGIC nfet L=0.7U W=10U AS=2.1P AD=2.1P
+ PS=10.42U PD=10.42U
* device instance $1051 r0 *1 55.65,648.04 nfet
M$1051 GND_DRV x3_lockout OUT GND_LOGIC nfet L=0.7U W=10U AS=2.1P AD=2.1P
+ PS=10.42U PD=10.42U
* device instance $1052 r0 *1 56.77,648.04 nfet
M$1052 OUT x3_lockout GND_DRV GND_LOGIC nfet L=0.7U W=10U AS=2.1P AD=2.1P
+ PS=10.42U PD=10.42U
* device instance $1053 r0 *1 57.89,648.04 nfet
M$1053 GND_DRV x3_lockout OUT GND_LOGIC nfet L=0.7U W=10U AS=2.1P AD=2.1P
+ PS=10.42U PD=10.42U
* device instance $1054 r0 *1 59.01,648.04 nfet
M$1054 OUT x3_lockout GND_DRV GND_LOGIC nfet L=0.7U W=10U AS=2.1P AD=2.1P
+ PS=10.42U PD=10.42U
* device instance $1055 r0 *1 60.13,648.04 nfet
M$1055 GND_DRV x3_lockout OUT GND_LOGIC nfet L=0.7U W=10U AS=2.1P AD=2.1P
+ PS=10.42U PD=10.42U
* device instance $1056 r0 *1 61.25,648.04 nfet
M$1056 OUT x3_lockout GND_DRV GND_LOGIC nfet L=0.7U W=10U AS=2.1P AD=2.1P
+ PS=10.42U PD=10.42U
* device instance $1057 r0 *1 62.37,648.04 nfet
M$1057 GND_DRV x3_lockout OUT GND_LOGIC nfet L=0.7U W=10U AS=2.1P AD=2.1P
+ PS=10.42U PD=10.42U
* device instance $1058 r0 *1 63.49,648.04 nfet
M$1058 OUT x3_lockout GND_DRV GND_LOGIC nfet L=0.7U W=10U AS=2.1P AD=2.1P
+ PS=10.42U PD=10.42U
* device instance $1059 r0 *1 64.61,648.04 nfet
M$1059 GND_DRV x3_lockout OUT GND_LOGIC nfet L=0.7U W=10U AS=2.1P AD=2.1P
+ PS=10.42U PD=10.42U
* device instance $1060 r0 *1 65.73,648.04 nfet
M$1060 OUT x3_lockout GND_DRV GND_LOGIC nfet L=0.7U W=10U AS=2.1P AD=2.1P
+ PS=10.42U PD=10.42U
* device instance $1061 r0 *1 66.85,648.04 nfet
M$1061 GND_DRV x3_lockout OUT GND_LOGIC nfet L=0.7U W=10U AS=2.1P AD=2.1P
+ PS=10.42U PD=10.42U
* device instance $1062 r0 *1 67.97,648.04 nfet
M$1062 OUT x3_lockout GND_DRV GND_LOGIC nfet L=0.7U W=10U AS=2.1P AD=2.1P
+ PS=10.42U PD=10.42U
* device instance $1063 r0 *1 69.09,648.04 nfet
M$1063 GND_DRV x3_lockout OUT GND_LOGIC nfet L=0.7U W=10U AS=2.1P AD=2.1P
+ PS=10.42U PD=10.42U
* device instance $1064 r0 *1 70.21,648.04 nfet
M$1064 OUT x3_lockout GND_DRV GND_LOGIC nfet L=0.7U W=10U AS=2.1P AD=2.1P
+ PS=10.42U PD=10.42U
* device instance $1065 r0 *1 71.33,648.04 nfet
M$1065 GND_DRV x3_lockout OUT GND_LOGIC nfet L=0.7U W=10U AS=2.1P AD=2.1P
+ PS=10.42U PD=10.42U
* device instance $1066 r0 *1 72.45,648.04 nfet
M$1066 OUT x3_lockout GND_DRV GND_LOGIC nfet L=0.7U W=10U AS=2.1P AD=2.1P
+ PS=10.42U PD=10.42U
* device instance $1067 r0 *1 73.57,648.04 nfet
M$1067 GND_DRV x3_lockout OUT GND_LOGIC nfet L=0.7U W=10U AS=2.1P AD=2.1P
+ PS=10.42U PD=10.42U
* device instance $1068 r0 *1 74.69,648.04 nfet
M$1068 OUT x3_lockout GND_DRV GND_LOGIC nfet L=0.7U W=10U AS=2.1P AD=2.1P
+ PS=10.42U PD=10.42U
* device instance $1069 r0 *1 75.81,648.04 nfet
M$1069 GND_DRV x3_lockout OUT GND_LOGIC nfet L=0.7U W=10U AS=2.1P AD=2.1P
+ PS=10.42U PD=10.42U
* device instance $1070 r0 *1 76.93,648.04 nfet
M$1070 OUT x3_lockout GND_DRV GND_LOGIC nfet L=0.7U W=10U AS=2.1P AD=2.1P
+ PS=10.42U PD=10.42U
* device instance $1071 r0 *1 78.05,648.04 nfet
M$1071 GND_DRV x3_lockout OUT GND_LOGIC nfet L=0.7U W=10U AS=2.1P AD=2.1P
+ PS=10.42U PD=10.42U
* device instance $1072 r0 *1 79.17,648.04 nfet
M$1072 OUT x3_lockout GND_DRV GND_LOGIC nfet L=0.7U W=10U AS=2.1P AD=2.1P
+ PS=10.42U PD=10.42U
* device instance $1073 r0 *1 80.29,648.04 nfet
M$1073 GND_DRV x3_lockout OUT GND_LOGIC nfet L=0.7U W=10U AS=2.1P AD=2.1P
+ PS=10.42U PD=10.42U
* device instance $1074 r0 *1 81.41,648.04 nfet
M$1074 OUT x3_lockout GND_DRV GND_LOGIC nfet L=0.7U W=10U AS=2.1P AD=2.1P
+ PS=10.42U PD=10.42U
* device instance $1075 r0 *1 82.53,648.04 nfet
M$1075 GND_DRV x3_lockout OUT GND_LOGIC nfet L=0.7U W=10U AS=2.1P AD=2.1P
+ PS=10.42U PD=10.42U
* device instance $1076 r0 *1 83.65,648.04 nfet
M$1076 OUT x3_lockout GND_DRV GND_LOGIC nfet L=0.7U W=10U AS=2.1P AD=2.1P
+ PS=10.42U PD=10.42U
* device instance $1077 r0 *1 84.77,648.04 nfet
M$1077 GND_DRV x3_lockout OUT GND_LOGIC nfet L=0.7U W=10U AS=2.1P AD=2.1P
+ PS=10.42U PD=10.42U
* device instance $1078 r0 *1 85.89,648.04 nfet
M$1078 OUT x3_lockout GND_DRV GND_LOGIC nfet L=0.7U W=10U AS=2.1P AD=2.1P
+ PS=10.42U PD=10.42U
* device instance $1079 r0 *1 87.01,648.04 nfet
M$1079 GND_DRV x3_lockout OUT GND_LOGIC nfet L=0.7U W=10U AS=2.1P AD=2.1P
+ PS=10.42U PD=10.42U
* device instance $1080 r0 *1 88.13,648.04 nfet
M$1080 OUT x3_lockout GND_DRV GND_LOGIC nfet L=0.7U W=10U AS=2.1P AD=2.1P
+ PS=10.42U PD=10.42U
* device instance $1081 r0 *1 89.25,648.04 nfet
M$1081 GND_DRV x3_lockout OUT GND_LOGIC nfet L=0.7U W=10U AS=2.1P AD=2.1P
+ PS=10.42U PD=10.42U
* device instance $1082 r0 *1 90.37,648.04 nfet
M$1082 OUT x3_lockout GND_DRV GND_LOGIC nfet L=0.7U W=10U AS=2.1P AD=2.1P
+ PS=10.42U PD=10.42U
* device instance $1083 r0 *1 91.49,648.04 nfet
M$1083 GND_DRV x3_lockout OUT GND_LOGIC nfet L=0.7U W=10U AS=2.1P AD=2.1P
+ PS=10.42U PD=10.42U
* device instance $1084 r0 *1 92.61,648.04 nfet
M$1084 OUT x3_lockout GND_DRV GND_LOGIC nfet L=0.7U W=10U AS=2.1P AD=2.1P
+ PS=10.42U PD=10.42U
* device instance $1085 r0 *1 93.73,648.04 nfet
M$1085 GND_DRV x3_lockout OUT GND_LOGIC nfet L=0.7U W=10U AS=2.1P AD=2.1P
+ PS=10.42U PD=10.42U
* device instance $1086 r0 *1 94.85,648.04 nfet
M$1086 OUT x3_lockout GND_DRV GND_LOGIC nfet L=0.7U W=10U AS=2.1P AD=2.1P
+ PS=10.42U PD=10.42U
* device instance $1087 r0 *1 95.97,648.04 nfet
M$1087 GND_DRV x3_lockout OUT GND_LOGIC nfet L=0.7U W=10U AS=2.1P AD=2.1P
+ PS=10.42U PD=10.42U
* device instance $1088 r0 *1 97.09,648.04 nfet
M$1088 OUT x3_lockout GND_DRV GND_LOGIC nfet L=0.7U W=10U AS=2.1P AD=2.1P
+ PS=10.42U PD=10.42U
* device instance $1089 r0 *1 98.21,648.04 nfet
M$1089 GND_DRV x3_lockout OUT GND_LOGIC nfet L=0.7U W=10U AS=2.1P AD=2.1P
+ PS=10.42U PD=10.42U
* device instance $1090 r0 *1 99.33,648.04 nfet
M$1090 OUT x3_lockout GND_DRV GND_LOGIC nfet L=0.7U W=10U AS=2.1P AD=2.1P
+ PS=10.42U PD=10.42U
* device instance $1091 r0 *1 100.45,648.04 nfet
M$1091 GND_DRV x3_lockout OUT GND_LOGIC nfet L=0.7U W=10U AS=2.1P AD=2.1P
+ PS=10.42U PD=10.42U
* device instance $1092 r0 *1 101.57,648.04 nfet
M$1092 OUT x3_lockout GND_DRV GND_LOGIC nfet L=0.7U W=10U AS=2.1P AD=2.1P
+ PS=10.42U PD=10.42U
* device instance $1093 r0 *1 102.69,648.04 nfet
M$1093 GND_DRV x3_lockout OUT GND_LOGIC nfet L=0.7U W=10U AS=2.1P AD=2.1P
+ PS=10.42U PD=10.42U
* device instance $1094 r0 *1 103.81,648.04 nfet
M$1094 OUT x3_lockout GND_DRV GND_LOGIC nfet L=0.7U W=10U AS=2.1P AD=2.1P
+ PS=10.42U PD=10.42U
* device instance $1095 r0 *1 104.93,648.04 nfet
M$1095 GND_DRV x3_lockout OUT GND_LOGIC nfet L=0.7U W=10U AS=2.1P AD=2.1P
+ PS=10.42U PD=10.42U
* device instance $1096 r0 *1 106.05,648.04 nfet
M$1096 OUT x3_lockout GND_DRV GND_LOGIC nfet L=0.7U W=10U AS=2.1P AD=2.1P
+ PS=10.42U PD=10.42U
* device instance $1097 r0 *1 107.17,648.04 nfet
M$1097 GND_DRV x3_lockout OUT GND_LOGIC nfet L=0.7U W=10U AS=2.1P AD=2.1P
+ PS=10.42U PD=10.42U
* device instance $1098 r0 *1 108.29,648.04 nfet
M$1098 OUT x3_lockout GND_DRV GND_LOGIC nfet L=0.7U W=10U AS=2.1P AD=2.1P
+ PS=10.42U PD=10.42U
* device instance $1099 r0 *1 109.41,648.04 nfet
M$1099 GND_DRV x3_lockout OUT GND_LOGIC nfet L=0.7U W=10U AS=2.1P AD=2.1P
+ PS=10.42U PD=10.42U
* device instance $1100 r0 *1 110.53,648.04 nfet
M$1100 OUT x3_lockout GND_DRV GND_LOGIC nfet L=0.7U W=10U AS=2.1P AD=2.1P
+ PS=10.42U PD=10.42U
* device instance $1101 r0 *1 111.65,648.04 nfet
M$1101 GND_DRV x3_lockout OUT GND_LOGIC nfet L=0.7U W=10U AS=2.1P AD=2.1P
+ PS=10.42U PD=10.42U
* device instance $1102 r0 *1 0.77,633.2 nfet
M$1102 x3_uvlo_ok x3_lockout GND_DRV GND_LOGIC nfet L=0.7U W=10U AS=4.2P
+ AD=4.2P PS=20.84U PD=20.84U
* device instance $1103 r0 *1 0.77,470.82 nfet
M$1103 x3_nref x3_nref GND_DRV GND_LOGIC nfet L=0.7U W=10U AS=4.2P AD=4.2P
+ PS=20.84U PD=20.84U
* device instance $1104 r0 *1 0.77,489.84 nfet
M$1104 x3_ntail x3_nref GND_DRV GND_LOGIC nfet L=0.7U W=20U AS=8.4P AD=8.4P
+ PS=40.84U PD=40.84U
* device instance $1105 r0 *1 0.77,530.38 nfet
M$1105 x3_ncompn x3_nref x3_ntail GND_LOGIC nfet L=0.7U W=15U AS=6.3P AD=6.3P
+ PS=30.84U PD=30.84U
* device instance $1106 r0 *1 0.77,511.36 nfet
M$1106 x3_ncompp x3_ndiv x3_ntail GND_LOGIC nfet L=0.7U W=15U AS=6.3P AD=6.3P
+ PS=30.84U PD=30.84U
* device instance $1107 r0 *1 0.695,137.87 pfet
M$1107 x1_nca x1_ncb VDD_DRV VDD_DRV pfet L=0.55U W=3U AS=1.26P AD=1.26P
+ PS=6.84U PD=6.84U
* device instance $1108 r0 *1 0.695,145.19 pfet
M$1108 x1_ncb x1_nca VDD_DRV VDD_DRV pfet L=0.55U W=3U AS=1.26P AD=1.26P
+ PS=6.84U PD=6.84U
* device instance $1109 r0 *1 0.695,153.51 pfet
M$1109 x1_nbuf1 x1_ncb VDD_DRV VDD_DRV pfet L=0.55U W=5U AS=2.1P AD=2.1P
+ PS=10.84U PD=10.84U
* device instance $1110 r0 *1 0.695,176.85 pfet
M$1110 IN_DRV x1_nbuf1 VDD_DRV VDD_DRV pfet L=0.55U W=15U AS=6.3P AD=6.3P
+ PS=30.84U PD=30.84U
* device instance $1111 r0 *1 0.695,209.89 pfet
M$1111 x2_n1 IN_DRV VDD_DRV VDD_DRV pfet L=0.55U W=4.4U AS=1.848P AD=1.848P
+ PS=9.64U PD=9.64U
* device instance $1112 r0 *1 0.695,231.43 pfet
M$1112 x2_n2 x2_n1 VDD_DRV VDD_DRV pfet L=0.55U W=18U AS=7.56P AD=7.56P
+ PS=36.84U PD=36.84U
* device instance $1113 r0 *1 0.695,293.27 pfet
M$1113 x2_n3 x2_n2 VDD_DRV VDD_DRV pfet L=0.55U W=73U AS=30.66P AD=30.66P
+ PS=146.84U PD=146.84U
* device instance $1114 r0 *1 0.695,376.93 pfet
M$1114 x2_n4 x2_n3 VDD_DRV VDD_DRV pfet L=0.55U W=10U AS=4.2P AD=2.1P PS=20.84U
+ PD=10.42U
* device instance $1115 r0 *1 1.665,376.93 pfet
M$1115 VDD_DRV x2_n3 x2_n4 VDD_DRV pfet L=0.55U W=10U AS=2.1P AD=2.1P PS=10.42U
+ PD=10.42U
* device instance $1116 r0 *1 2.635,376.93 pfet
M$1116 x2_n4 x2_n3 VDD_DRV VDD_DRV pfet L=0.55U W=10U AS=2.1P AD=2.1P PS=10.42U
+ PD=10.42U
* device instance $1117 r0 *1 3.605,376.93 pfet
M$1117 VDD_DRV x2_n3 x2_n4 VDD_DRV pfet L=0.55U W=10U AS=2.1P AD=2.1P PS=10.42U
+ PD=10.42U
* device instance $1118 r0 *1 4.575,376.93 pfet
M$1118 x2_n4 x2_n3 VDD_DRV VDD_DRV pfet L=0.55U W=10U AS=2.1P AD=2.1P PS=10.42U
+ PD=10.42U
* device instance $1119 r0 *1 5.545,376.93 pfet
M$1119 VDD_DRV x2_n3 x2_n4 VDD_DRV pfet L=0.55U W=10U AS=2.1P AD=2.1P PS=10.42U
+ PD=10.42U
* device instance $1120 r0 *1 6.515,376.93 pfet
M$1120 x2_n4 x2_n3 VDD_DRV VDD_DRV pfet L=0.55U W=10U AS=2.1P AD=2.1P PS=10.42U
+ PD=10.42U
* device instance $1121 r0 *1 7.485,376.93 pfet
M$1121 VDD_DRV x2_n3 x2_n4 VDD_DRV pfet L=0.55U W=10U AS=2.1P AD=2.1P PS=10.42U
+ PD=10.42U
* device instance $1122 r0 *1 8.455,376.93 pfet
M$1122 x2_n4 x2_n3 VDD_DRV VDD_DRV pfet L=0.55U W=10U AS=2.1P AD=2.1P PS=10.42U
+ PD=10.42U
* device instance $1123 r0 *1 9.425,376.93 pfet
M$1123 VDD_DRV x2_n3 x2_n4 VDD_DRV pfet L=0.55U W=10U AS=2.1P AD=2.1P PS=10.42U
+ PD=10.42U
* device instance $1124 r0 *1 10.395,376.93 pfet
M$1124 x2_n4 x2_n3 VDD_DRV VDD_DRV pfet L=0.55U W=10U AS=2.1P AD=2.1P PS=10.42U
+ PD=10.42U
* device instance $1125 r0 *1 11.365,376.93 pfet
M$1125 VDD_DRV x2_n3 x2_n4 VDD_DRV pfet L=0.55U W=10U AS=2.1P AD=2.1P PS=10.42U
+ PD=10.42U
* device instance $1126 r0 *1 12.335,376.93 pfet
M$1126 x2_n4 x2_n3 VDD_DRV VDD_DRV pfet L=0.55U W=10U AS=2.1P AD=2.1P PS=10.42U
+ PD=10.42U
* device instance $1127 r0 *1 13.305,376.93 pfet
M$1127 VDD_DRV x2_n3 x2_n4 VDD_DRV pfet L=0.55U W=10U AS=2.1P AD=2.1P PS=10.42U
+ PD=10.42U
* device instance $1128 r0 *1 14.275,376.93 pfet
M$1128 x2_n4 x2_n3 VDD_DRV VDD_DRV pfet L=0.55U W=10U AS=2.1P AD=2.1P PS=10.42U
+ PD=10.42U
* device instance $1129 r0 *1 15.245,376.93 pfet
M$1129 VDD_DRV x2_n3 x2_n4 VDD_DRV pfet L=0.55U W=10U AS=2.1P AD=2.1P PS=10.42U
+ PD=10.42U
* device instance $1130 r0 *1 16.215,376.93 pfet
M$1130 x2_n4 x2_n3 VDD_DRV VDD_DRV pfet L=0.55U W=10U AS=2.1P AD=2.1P PS=10.42U
+ PD=10.42U
* device instance $1131 r0 *1 17.185,376.93 pfet
M$1131 VDD_DRV x2_n3 x2_n4 VDD_DRV pfet L=0.55U W=10U AS=2.1P AD=2.1P PS=10.42U
+ PD=10.42U
* device instance $1132 r0 *1 18.155,376.93 pfet
M$1132 x2_n4 x2_n3 VDD_DRV VDD_DRV pfet L=0.55U W=10U AS=2.1P AD=2.1P PS=10.42U
+ PD=10.42U
* device instance $1133 r0 *1 19.125,376.93 pfet
M$1133 VDD_DRV x2_n3 x2_n4 VDD_DRV pfet L=0.55U W=10U AS=2.1P AD=2.1P PS=10.42U
+ PD=10.42U
* device instance $1134 r0 *1 20.095,376.93 pfet
M$1134 x2_n4 x2_n3 VDD_DRV VDD_DRV pfet L=0.55U W=10U AS=2.1P AD=2.1P PS=10.42U
+ PD=10.42U
* device instance $1135 r0 *1 21.065,376.93 pfet
M$1135 VDD_DRV x2_n3 x2_n4 VDD_DRV pfet L=0.55U W=10U AS=2.1P AD=2.1P PS=10.42U
+ PD=10.42U
* device instance $1136 r0 *1 22.035,376.93 pfet
M$1136 x2_n4 x2_n3 VDD_DRV VDD_DRV pfet L=0.55U W=10U AS=2.1P AD=2.1P PS=10.42U
+ PD=10.42U
* device instance $1137 r0 *1 23.005,376.93 pfet
M$1137 VDD_DRV x2_n3 x2_n4 VDD_DRV pfet L=0.55U W=10U AS=2.1P AD=2.1P PS=10.42U
+ PD=10.42U
* device instance $1138 r0 *1 23.975,376.93 pfet
M$1138 x2_n4 x2_n3 VDD_DRV VDD_DRV pfet L=0.55U W=10U AS=2.1P AD=2.1P PS=10.42U
+ PD=10.42U
* device instance $1139 r0 *1 24.945,376.93 pfet
M$1139 VDD_DRV x2_n3 x2_n4 VDD_DRV pfet L=0.55U W=10U AS=2.1P AD=2.1P PS=10.42U
+ PD=10.42U
* device instance $1140 r0 *1 25.915,376.93 pfet
M$1140 x2_n4 x2_n3 VDD_DRV VDD_DRV pfet L=0.55U W=10U AS=2.1P AD=2.1P PS=10.42U
+ PD=10.42U
* device instance $1141 r0 *1 26.885,376.93 pfet
M$1141 VDD_DRV x2_n3 x2_n4 VDD_DRV pfet L=0.55U W=10U AS=2.1P AD=2.1P PS=10.42U
+ PD=10.42U
* device instance $1142 r0 *1 27.855,376.93 pfet
M$1142 x2_n4 x2_n3 VDD_DRV VDD_DRV pfet L=0.55U W=10U AS=2.1P AD=2.1P PS=10.42U
+ PD=10.42U
* device instance $1143 r0 *1 28.825,376.93 pfet
M$1143 VDD_DRV x2_n3 x2_n4 VDD_DRV pfet L=0.55U W=10U AS=2.1P AD=4.2P PS=10.42U
+ PD=20.84U
* device instance $1144 r0 *1 59.865,408.55 pfet
M$1144 VDD_DRV x2_n4 x2_n5 VDD_DRV pfet L=0.55U W=10U AS=2.1P AD=2.1P PS=10.42U
+ PD=10.42U
* device instance $1145 r0 *1 60.835,408.55 pfet
M$1145 x2_n5 x2_n4 VDD_DRV VDD_DRV pfet L=0.55U W=10U AS=2.1P AD=2.1P PS=10.42U
+ PD=10.42U
* device instance $1146 r0 *1 61.805,408.55 pfet
M$1146 VDD_DRV x2_n4 x2_n5 VDD_DRV pfet L=0.55U W=10U AS=2.1P AD=2.1P PS=10.42U
+ PD=10.42U
* device instance $1147 r0 *1 62.775,408.55 pfet
M$1147 x2_n5 x2_n4 VDD_DRV VDD_DRV pfet L=0.55U W=10U AS=2.1P AD=2.1P PS=10.42U
+ PD=10.42U
* device instance $1148 r0 *1 63.745,408.55 pfet
M$1148 VDD_DRV x2_n4 x2_n5 VDD_DRV pfet L=0.55U W=10U AS=2.1P AD=2.1P PS=10.42U
+ PD=10.42U
* device instance $1149 r0 *1 64.715,408.55 pfet
M$1149 x2_n5 x2_n4 VDD_DRV VDD_DRV pfet L=0.55U W=10U AS=2.1P AD=2.1P PS=10.42U
+ PD=10.42U
* device instance $1150 r0 *1 65.685,408.55 pfet
M$1150 VDD_DRV x2_n4 x2_n5 VDD_DRV pfet L=0.55U W=10U AS=2.1P AD=2.1P PS=10.42U
+ PD=10.42U
* device instance $1151 r0 *1 66.655,408.55 pfet
M$1151 x2_n5 x2_n4 VDD_DRV VDD_DRV pfet L=0.55U W=10U AS=2.1P AD=2.1P PS=10.42U
+ PD=10.42U
* device instance $1152 r0 *1 67.625,408.55 pfet
M$1152 VDD_DRV x2_n4 x2_n5 VDD_DRV pfet L=0.55U W=10U AS=2.1P AD=2.1P PS=10.42U
+ PD=10.42U
* device instance $1153 r0 *1 68.595,408.55 pfet
M$1153 x2_n5 x2_n4 VDD_DRV VDD_DRV pfet L=0.55U W=10U AS=2.1P AD=2.1P PS=10.42U
+ PD=10.42U
* device instance $1154 r0 *1 69.565,408.55 pfet
M$1154 VDD_DRV x2_n4 x2_n5 VDD_DRV pfet L=0.55U W=10U AS=2.1P AD=2.1P PS=10.42U
+ PD=10.42U
* device instance $1155 r0 *1 70.535,408.55 pfet
M$1155 x2_n5 x2_n4 VDD_DRV VDD_DRV pfet L=0.55U W=10U AS=2.1P AD=2.1P PS=10.42U
+ PD=10.42U
* device instance $1156 r0 *1 71.505,408.55 pfet
M$1156 VDD_DRV x2_n4 x2_n5 VDD_DRV pfet L=0.55U W=10U AS=2.1P AD=2.1P PS=10.42U
+ PD=10.42U
* device instance $1157 r0 *1 72.475,408.55 pfet
M$1157 x2_n5 x2_n4 VDD_DRV VDD_DRV pfet L=0.55U W=10U AS=2.1P AD=2.1P PS=10.42U
+ PD=10.42U
* device instance $1158 r0 *1 73.445,408.55 pfet
M$1158 VDD_DRV x2_n4 x2_n5 VDD_DRV pfet L=0.55U W=10U AS=2.1P AD=2.1P PS=10.42U
+ PD=10.42U
* device instance $1159 r0 *1 74.415,408.55 pfet
M$1159 x2_n5 x2_n4 VDD_DRV VDD_DRV pfet L=0.55U W=10U AS=2.1P AD=2.1P PS=10.42U
+ PD=10.42U
* device instance $1160 r0 *1 75.385,408.55 pfet
M$1160 VDD_DRV x2_n4 x2_n5 VDD_DRV pfet L=0.55U W=10U AS=2.1P AD=2.1P PS=10.42U
+ PD=10.42U
* device instance $1161 r0 *1 76.355,408.55 pfet
M$1161 x2_n5 x2_n4 VDD_DRV VDD_DRV pfet L=0.55U W=10U AS=2.1P AD=2.1P PS=10.42U
+ PD=10.42U
* device instance $1162 r0 *1 77.325,408.55 pfet
M$1162 VDD_DRV x2_n4 x2_n5 VDD_DRV pfet L=0.55U W=10U AS=2.1P AD=2.1P PS=10.42U
+ PD=10.42U
* device instance $1163 r0 *1 78.295,408.55 pfet
M$1163 x2_n5 x2_n4 VDD_DRV VDD_DRV pfet L=0.55U W=10U AS=2.1P AD=2.1P PS=10.42U
+ PD=10.42U
* device instance $1164 r0 *1 79.265,408.55 pfet
M$1164 VDD_DRV x2_n4 x2_n5 VDD_DRV pfet L=0.55U W=10U AS=2.1P AD=2.1P PS=10.42U
+ PD=10.42U
* device instance $1165 r0 *1 80.235,408.55 pfet
M$1165 x2_n5 x2_n4 VDD_DRV VDD_DRV pfet L=0.55U W=10U AS=2.1P AD=2.1P PS=10.42U
+ PD=10.42U
* device instance $1166 r0 *1 81.205,408.55 pfet
M$1166 VDD_DRV x2_n4 x2_n5 VDD_DRV pfet L=0.55U W=10U AS=2.1P AD=2.1P PS=10.42U
+ PD=10.42U
* device instance $1167 r0 *1 82.175,408.55 pfet
M$1167 x2_n5 x2_n4 VDD_DRV VDD_DRV pfet L=0.55U W=10U AS=2.1P AD=2.1P PS=10.42U
+ PD=10.42U
* device instance $1168 r0 *1 83.145,408.55 pfet
M$1168 VDD_DRV x2_n4 x2_n5 VDD_DRV pfet L=0.55U W=10U AS=2.1P AD=2.1P PS=10.42U
+ PD=10.42U
* device instance $1169 r0 *1 84.115,408.55 pfet
M$1169 x2_n5 x2_n4 VDD_DRV VDD_DRV pfet L=0.55U W=10U AS=2.1P AD=2.1P PS=10.42U
+ PD=10.42U
* device instance $1170 r0 *1 85.085,408.55 pfet
M$1170 VDD_DRV x2_n4 x2_n5 VDD_DRV pfet L=0.55U W=10U AS=2.1P AD=2.1P PS=10.42U
+ PD=10.42U
* device instance $1171 r0 *1 86.055,408.55 pfet
M$1171 x2_n5 x2_n4 VDD_DRV VDD_DRV pfet L=0.55U W=10U AS=2.1P AD=2.1P PS=10.42U
+ PD=10.42U
* device instance $1172 r0 *1 87.025,408.55 pfet
M$1172 VDD_DRV x2_n4 x2_n5 VDD_DRV pfet L=0.55U W=10U AS=2.1P AD=2.1P PS=10.42U
+ PD=10.42U
* device instance $1173 r0 *1 87.995,408.55 pfet
M$1173 x2_n5 x2_n4 VDD_DRV VDD_DRV pfet L=0.55U W=10U AS=2.1P AD=2.1P PS=10.42U
+ PD=10.42U
* device instance $1174 r0 *1 88.965,408.55 pfet
M$1174 VDD_DRV x2_n4 x2_n5 VDD_DRV pfet L=0.55U W=10U AS=2.1P AD=2.1P PS=10.42U
+ PD=10.42U
* device instance $1175 r0 *1 89.935,408.55 pfet
M$1175 x2_n5 x2_n4 VDD_DRV VDD_DRV pfet L=0.55U W=10U AS=2.1P AD=2.1P PS=10.42U
+ PD=10.42U
* device instance $1176 r0 *1 90.905,408.55 pfet
M$1176 VDD_DRV x2_n4 x2_n5 VDD_DRV pfet L=0.55U W=10U AS=2.1P AD=2.1P PS=10.42U
+ PD=10.42U
* device instance $1177 r0 *1 91.875,408.55 pfet
M$1177 x2_n5 x2_n4 VDD_DRV VDD_DRV pfet L=0.55U W=10U AS=2.1P AD=2.1P PS=10.42U
+ PD=10.42U
* device instance $1178 r0 *1 92.845,408.55 pfet
M$1178 VDD_DRV x2_n4 x2_n5 VDD_DRV pfet L=0.55U W=10U AS=2.1P AD=2.1P PS=10.42U
+ PD=10.42U
* device instance $1179 r0 *1 93.815,408.55 pfet
M$1179 x2_n5 x2_n4 VDD_DRV VDD_DRV pfet L=0.55U W=10U AS=2.1P AD=2.1P PS=10.42U
+ PD=10.42U
* device instance $1180 r0 *1 94.785,408.55 pfet
M$1180 VDD_DRV x2_n4 x2_n5 VDD_DRV pfet L=0.55U W=10U AS=2.1P AD=2.1P PS=10.42U
+ PD=10.42U
* device instance $1181 r0 *1 95.755,408.55 pfet
M$1181 x2_n5 x2_n4 VDD_DRV VDD_DRV pfet L=0.55U W=10U AS=2.1P AD=2.1P PS=10.42U
+ PD=10.42U
* device instance $1182 r0 *1 96.725,408.55 pfet
M$1182 VDD_DRV x2_n4 x2_n5 VDD_DRV pfet L=0.55U W=10U AS=2.1P AD=2.1P PS=10.42U
+ PD=10.42U
* device instance $1183 r0 *1 97.695,408.55 pfet
M$1183 x2_n5 x2_n4 VDD_DRV VDD_DRV pfet L=0.55U W=10U AS=2.1P AD=2.1P PS=10.42U
+ PD=10.42U
* device instance $1184 r0 *1 98.665,408.55 pfet
M$1184 VDD_DRV x2_n4 x2_n5 VDD_DRV pfet L=0.55U W=10U AS=2.1P AD=2.1P PS=10.42U
+ PD=10.42U
* device instance $1185 r0 *1 99.635,408.55 pfet
M$1185 x2_n5 x2_n4 VDD_DRV VDD_DRV pfet L=0.55U W=10U AS=2.1P AD=2.1P PS=10.42U
+ PD=10.42U
* device instance $1186 r0 *1 100.605,408.55 pfet
M$1186 VDD_DRV x2_n4 x2_n5 VDD_DRV pfet L=0.55U W=10U AS=2.1P AD=2.1P PS=10.42U
+ PD=10.42U
* device instance $1187 r0 *1 101.575,408.55 pfet
M$1187 x2_n5 x2_n4 VDD_DRV VDD_DRV pfet L=0.55U W=10U AS=2.1P AD=2.1P PS=10.42U
+ PD=10.42U
* device instance $1188 r0 *1 102.545,408.55 pfet
M$1188 VDD_DRV x2_n4 x2_n5 VDD_DRV pfet L=0.55U W=10U AS=2.1P AD=2.1P PS=10.42U
+ PD=10.42U
* device instance $1189 r0 *1 103.515,408.55 pfet
M$1189 x2_n5 x2_n4 VDD_DRV VDD_DRV pfet L=0.55U W=10U AS=2.1P AD=2.1P PS=10.42U
+ PD=10.42U
* device instance $1190 r0 *1 104.485,408.55 pfet
M$1190 VDD_DRV x2_n4 x2_n5 VDD_DRV pfet L=0.55U W=10U AS=2.1P AD=2.1P PS=10.42U
+ PD=10.42U
* device instance $1191 r0 *1 105.455,408.55 pfet
M$1191 x2_n5 x2_n4 VDD_DRV VDD_DRV pfet L=0.55U W=10U AS=2.1P AD=2.1P PS=10.42U
+ PD=10.42U
* device instance $1192 r0 *1 106.425,408.55 pfet
M$1192 VDD_DRV x2_n4 x2_n5 VDD_DRV pfet L=0.55U W=10U AS=2.1P AD=2.1P PS=10.42U
+ PD=10.42U
* device instance $1193 r0 *1 107.395,408.55 pfet
M$1193 x2_n5 x2_n4 VDD_DRV VDD_DRV pfet L=0.55U W=10U AS=2.1P AD=2.1P PS=10.42U
+ PD=10.42U
* device instance $1194 r0 *1 108.365,408.55 pfet
M$1194 VDD_DRV x2_n4 x2_n5 VDD_DRV pfet L=0.55U W=10U AS=2.1P AD=2.1P PS=10.42U
+ PD=10.42U
* device instance $1195 r0 *1 109.335,408.55 pfet
M$1195 x2_n5 x2_n4 VDD_DRV VDD_DRV pfet L=0.55U W=10U AS=2.1P AD=2.1P PS=10.42U
+ PD=10.42U
* device instance $1196 r0 *1 110.305,408.55 pfet
M$1196 VDD_DRV x2_n4 x2_n5 VDD_DRV pfet L=0.55U W=10U AS=2.1P AD=2.1P PS=10.42U
+ PD=10.42U
* device instance $1197 r0 *1 111.275,408.55 pfet
M$1197 x2_n5 x2_n4 VDD_DRV VDD_DRV pfet L=0.55U W=10U AS=2.1P AD=2.1P PS=10.42U
+ PD=10.42U
* device instance $1198 r0 *1 112.245,408.55 pfet
M$1198 VDD_DRV x2_n4 x2_n5 VDD_DRV pfet L=0.55U W=10U AS=2.1P AD=2.1P PS=10.42U
+ PD=10.42U
* device instance $1199 r0 *1 113.215,408.55 pfet
M$1199 x2_n5 x2_n4 VDD_DRV VDD_DRV pfet L=0.55U W=10U AS=2.1P AD=2.1P PS=10.42U
+ PD=10.42U
* device instance $1200 r0 *1 114.185,408.55 pfet
M$1200 VDD_DRV x2_n4 x2_n5 VDD_DRV pfet L=0.55U W=10U AS=2.1P AD=2.1P PS=10.42U
+ PD=10.42U
* device instance $1201 r0 *1 115.155,408.55 pfet
M$1201 x2_n5 x2_n4 VDD_DRV VDD_DRV pfet L=0.55U W=10U AS=2.1P AD=2.1P PS=10.42U
+ PD=10.42U
* device instance $1202 r0 *1 116.125,408.55 pfet
M$1202 VDD_DRV x2_n4 x2_n5 VDD_DRV pfet L=0.55U W=10U AS=2.1P AD=2.1P PS=10.42U
+ PD=10.42U
* device instance $1203 r0 *1 117.095,408.55 pfet
M$1203 x2_n5 x2_n4 VDD_DRV VDD_DRV pfet L=0.55U W=10U AS=2.1P AD=2.1P PS=10.42U
+ PD=10.42U
* device instance $1204 r0 *1 118.065,408.55 pfet
M$1204 VDD_DRV x2_n4 x2_n5 VDD_DRV pfet L=0.55U W=10U AS=2.1P AD=4.2P PS=10.42U
+ PD=20.84U
* device instance $1205 r0 *1 0.695,408.55 pfet
M$1205 x2_n5 x2_n4 VDD_DRV VDD_DRV pfet L=0.55U W=10U AS=4.2P AD=2.1P PS=20.84U
+ PD=10.42U
* device instance $1206 r0 *1 1.665,408.55 pfet
M$1206 VDD_DRV x2_n4 x2_n5 VDD_DRV pfet L=0.55U W=10U AS=2.1P AD=2.1P PS=10.42U
+ PD=10.42U
* device instance $1207 r0 *1 2.635,408.55 pfet
M$1207 x2_n5 x2_n4 VDD_DRV VDD_DRV pfet L=0.55U W=10U AS=2.1P AD=2.1P PS=10.42U
+ PD=10.42U
* device instance $1208 r0 *1 3.605,408.55 pfet
M$1208 VDD_DRV x2_n4 x2_n5 VDD_DRV pfet L=0.55U W=10U AS=2.1P AD=2.1P PS=10.42U
+ PD=10.42U
* device instance $1209 r0 *1 4.575,408.55 pfet
M$1209 x2_n5 x2_n4 VDD_DRV VDD_DRV pfet L=0.55U W=10U AS=2.1P AD=2.1P PS=10.42U
+ PD=10.42U
* device instance $1210 r0 *1 5.545,408.55 pfet
M$1210 VDD_DRV x2_n4 x2_n5 VDD_DRV pfet L=0.55U W=10U AS=2.1P AD=2.1P PS=10.42U
+ PD=10.42U
* device instance $1211 r0 *1 6.515,408.55 pfet
M$1211 x2_n5 x2_n4 VDD_DRV VDD_DRV pfet L=0.55U W=10U AS=2.1P AD=2.1P PS=10.42U
+ PD=10.42U
* device instance $1212 r0 *1 7.485,408.55 pfet
M$1212 VDD_DRV x2_n4 x2_n5 VDD_DRV pfet L=0.55U W=10U AS=2.1P AD=2.1P PS=10.42U
+ PD=10.42U
* device instance $1213 r0 *1 8.455,408.55 pfet
M$1213 x2_n5 x2_n4 VDD_DRV VDD_DRV pfet L=0.55U W=10U AS=2.1P AD=2.1P PS=10.42U
+ PD=10.42U
* device instance $1214 r0 *1 9.425,408.55 pfet
M$1214 VDD_DRV x2_n4 x2_n5 VDD_DRV pfet L=0.55U W=10U AS=2.1P AD=2.1P PS=10.42U
+ PD=10.42U
* device instance $1215 r0 *1 10.395,408.55 pfet
M$1215 x2_n5 x2_n4 VDD_DRV VDD_DRV pfet L=0.55U W=10U AS=2.1P AD=2.1P PS=10.42U
+ PD=10.42U
* device instance $1216 r0 *1 11.365,408.55 pfet
M$1216 VDD_DRV x2_n4 x2_n5 VDD_DRV pfet L=0.55U W=10U AS=2.1P AD=2.1P PS=10.42U
+ PD=10.42U
* device instance $1217 r0 *1 12.335,408.55 pfet
M$1217 x2_n5 x2_n4 VDD_DRV VDD_DRV pfet L=0.55U W=10U AS=2.1P AD=2.1P PS=10.42U
+ PD=10.42U
* device instance $1218 r0 *1 13.305,408.55 pfet
M$1218 VDD_DRV x2_n4 x2_n5 VDD_DRV pfet L=0.55U W=10U AS=2.1P AD=2.1P PS=10.42U
+ PD=10.42U
* device instance $1219 r0 *1 14.275,408.55 pfet
M$1219 x2_n5 x2_n4 VDD_DRV VDD_DRV pfet L=0.55U W=10U AS=2.1P AD=2.1P PS=10.42U
+ PD=10.42U
* device instance $1220 r0 *1 15.245,408.55 pfet
M$1220 VDD_DRV x2_n4 x2_n5 VDD_DRV pfet L=0.55U W=10U AS=2.1P AD=2.1P PS=10.42U
+ PD=10.42U
* device instance $1221 r0 *1 16.215,408.55 pfet
M$1221 x2_n5 x2_n4 VDD_DRV VDD_DRV pfet L=0.55U W=10U AS=2.1P AD=2.1P PS=10.42U
+ PD=10.42U
* device instance $1222 r0 *1 17.185,408.55 pfet
M$1222 VDD_DRV x2_n4 x2_n5 VDD_DRV pfet L=0.55U W=10U AS=2.1P AD=2.1P PS=10.42U
+ PD=10.42U
* device instance $1223 r0 *1 18.155,408.55 pfet
M$1223 x2_n5 x2_n4 VDD_DRV VDD_DRV pfet L=0.55U W=10U AS=2.1P AD=2.1P PS=10.42U
+ PD=10.42U
* device instance $1224 r0 *1 19.125,408.55 pfet
M$1224 VDD_DRV x2_n4 x2_n5 VDD_DRV pfet L=0.55U W=10U AS=2.1P AD=2.1P PS=10.42U
+ PD=10.42U
* device instance $1225 r0 *1 20.095,408.55 pfet
M$1225 x2_n5 x2_n4 VDD_DRV VDD_DRV pfet L=0.55U W=10U AS=2.1P AD=2.1P PS=10.42U
+ PD=10.42U
* device instance $1226 r0 *1 21.065,408.55 pfet
M$1226 VDD_DRV x2_n4 x2_n5 VDD_DRV pfet L=0.55U W=10U AS=2.1P AD=2.1P PS=10.42U
+ PD=10.42U
* device instance $1227 r0 *1 22.035,408.55 pfet
M$1227 x2_n5 x2_n4 VDD_DRV VDD_DRV pfet L=0.55U W=10U AS=2.1P AD=2.1P PS=10.42U
+ PD=10.42U
* device instance $1228 r0 *1 23.005,408.55 pfet
M$1228 VDD_DRV x2_n4 x2_n5 VDD_DRV pfet L=0.55U W=10U AS=2.1P AD=2.1P PS=10.42U
+ PD=10.42U
* device instance $1229 r0 *1 23.975,408.55 pfet
M$1229 x2_n5 x2_n4 VDD_DRV VDD_DRV pfet L=0.55U W=10U AS=2.1P AD=2.1P PS=10.42U
+ PD=10.42U
* device instance $1230 r0 *1 24.945,408.55 pfet
M$1230 VDD_DRV x2_n4 x2_n5 VDD_DRV pfet L=0.55U W=10U AS=2.1P AD=2.1P PS=10.42U
+ PD=10.42U
* device instance $1231 r0 *1 25.915,408.55 pfet
M$1231 x2_n5 x2_n4 VDD_DRV VDD_DRV pfet L=0.55U W=10U AS=2.1P AD=2.1P PS=10.42U
+ PD=10.42U
* device instance $1232 r0 *1 26.885,408.55 pfet
M$1232 VDD_DRV x2_n4 x2_n5 VDD_DRV pfet L=0.55U W=10U AS=2.1P AD=2.1P PS=10.42U
+ PD=10.42U
* device instance $1233 r0 *1 27.855,408.55 pfet
M$1233 x2_n5 x2_n4 VDD_DRV VDD_DRV pfet L=0.55U W=10U AS=2.1P AD=2.1P PS=10.42U
+ PD=10.42U
* device instance $1234 r0 *1 28.825,408.55 pfet
M$1234 VDD_DRV x2_n4 x2_n5 VDD_DRV pfet L=0.55U W=10U AS=2.1P AD=2.1P PS=10.42U
+ PD=10.42U
* device instance $1235 r0 *1 29.795,408.55 pfet
M$1235 x2_n5 x2_n4 VDD_DRV VDD_DRV pfet L=0.55U W=10U AS=2.1P AD=2.1P PS=10.42U
+ PD=10.42U
* device instance $1236 r0 *1 30.765,408.55 pfet
M$1236 VDD_DRV x2_n4 x2_n5 VDD_DRV pfet L=0.55U W=10U AS=2.1P AD=2.1P PS=10.42U
+ PD=10.42U
* device instance $1237 r0 *1 31.735,408.55 pfet
M$1237 x2_n5 x2_n4 VDD_DRV VDD_DRV pfet L=0.55U W=10U AS=2.1P AD=2.1P PS=10.42U
+ PD=10.42U
* device instance $1238 r0 *1 32.705,408.55 pfet
M$1238 VDD_DRV x2_n4 x2_n5 VDD_DRV pfet L=0.55U W=10U AS=2.1P AD=2.1P PS=10.42U
+ PD=10.42U
* device instance $1239 r0 *1 33.675,408.55 pfet
M$1239 x2_n5 x2_n4 VDD_DRV VDD_DRV pfet L=0.55U W=10U AS=2.1P AD=2.1P PS=10.42U
+ PD=10.42U
* device instance $1240 r0 *1 34.645,408.55 pfet
M$1240 VDD_DRV x2_n4 x2_n5 VDD_DRV pfet L=0.55U W=10U AS=2.1P AD=2.1P PS=10.42U
+ PD=10.42U
* device instance $1241 r0 *1 35.615,408.55 pfet
M$1241 x2_n5 x2_n4 VDD_DRV VDD_DRV pfet L=0.55U W=10U AS=2.1P AD=2.1P PS=10.42U
+ PD=10.42U
* device instance $1242 r0 *1 36.585,408.55 pfet
M$1242 VDD_DRV x2_n4 x2_n5 VDD_DRV pfet L=0.55U W=10U AS=2.1P AD=2.1P PS=10.42U
+ PD=10.42U
* device instance $1243 r0 *1 37.555,408.55 pfet
M$1243 x2_n5 x2_n4 VDD_DRV VDD_DRV pfet L=0.55U W=10U AS=2.1P AD=2.1P PS=10.42U
+ PD=10.42U
* device instance $1244 r0 *1 38.525,408.55 pfet
M$1244 VDD_DRV x2_n4 x2_n5 VDD_DRV pfet L=0.55U W=10U AS=2.1P AD=2.1P PS=10.42U
+ PD=10.42U
* device instance $1245 r0 *1 39.495,408.55 pfet
M$1245 x2_n5 x2_n4 VDD_DRV VDD_DRV pfet L=0.55U W=10U AS=2.1P AD=2.1P PS=10.42U
+ PD=10.42U
* device instance $1246 r0 *1 40.465,408.55 pfet
M$1246 VDD_DRV x2_n4 x2_n5 VDD_DRV pfet L=0.55U W=10U AS=2.1P AD=2.1P PS=10.42U
+ PD=10.42U
* device instance $1247 r0 *1 41.435,408.55 pfet
M$1247 x2_n5 x2_n4 VDD_DRV VDD_DRV pfet L=0.55U W=10U AS=2.1P AD=2.1P PS=10.42U
+ PD=10.42U
* device instance $1248 r0 *1 42.405,408.55 pfet
M$1248 VDD_DRV x2_n4 x2_n5 VDD_DRV pfet L=0.55U W=10U AS=2.1P AD=2.1P PS=10.42U
+ PD=10.42U
* device instance $1249 r0 *1 43.375,408.55 pfet
M$1249 x2_n5 x2_n4 VDD_DRV VDD_DRV pfet L=0.55U W=10U AS=2.1P AD=2.1P PS=10.42U
+ PD=10.42U
* device instance $1250 r0 *1 44.345,408.55 pfet
M$1250 VDD_DRV x2_n4 x2_n5 VDD_DRV pfet L=0.55U W=10U AS=2.1P AD=2.1P PS=10.42U
+ PD=10.42U
* device instance $1251 r0 *1 45.315,408.55 pfet
M$1251 x2_n5 x2_n4 VDD_DRV VDD_DRV pfet L=0.55U W=10U AS=2.1P AD=2.1P PS=10.42U
+ PD=10.42U
* device instance $1252 r0 *1 46.285,408.55 pfet
M$1252 VDD_DRV x2_n4 x2_n5 VDD_DRV pfet L=0.55U W=10U AS=2.1P AD=2.1P PS=10.42U
+ PD=10.42U
* device instance $1253 r0 *1 47.255,408.55 pfet
M$1253 x2_n5 x2_n4 VDD_DRV VDD_DRV pfet L=0.55U W=10U AS=2.1P AD=2.1P PS=10.42U
+ PD=10.42U
* device instance $1254 r0 *1 48.225,408.55 pfet
M$1254 VDD_DRV x2_n4 x2_n5 VDD_DRV pfet L=0.55U W=10U AS=2.1P AD=2.1P PS=10.42U
+ PD=10.42U
* device instance $1255 r0 *1 49.195,408.55 pfet
M$1255 x2_n5 x2_n4 VDD_DRV VDD_DRV pfet L=0.55U W=10U AS=2.1P AD=2.1P PS=10.42U
+ PD=10.42U
* device instance $1256 r0 *1 50.165,408.55 pfet
M$1256 VDD_DRV x2_n4 x2_n5 VDD_DRV pfet L=0.55U W=10U AS=2.1P AD=2.1P PS=10.42U
+ PD=10.42U
* device instance $1257 r0 *1 51.135,408.55 pfet
M$1257 x2_n5 x2_n4 VDD_DRV VDD_DRV pfet L=0.55U W=10U AS=2.1P AD=2.1P PS=10.42U
+ PD=10.42U
* device instance $1258 r0 *1 52.105,408.55 pfet
M$1258 VDD_DRV x2_n4 x2_n5 VDD_DRV pfet L=0.55U W=10U AS=2.1P AD=2.1P PS=10.42U
+ PD=10.42U
* device instance $1259 r0 *1 53.075,408.55 pfet
M$1259 x2_n5 x2_n4 VDD_DRV VDD_DRV pfet L=0.55U W=10U AS=2.1P AD=2.1P PS=10.42U
+ PD=10.42U
* device instance $1260 r0 *1 54.045,408.55 pfet
M$1260 VDD_DRV x2_n4 x2_n5 VDD_DRV pfet L=0.55U W=10U AS=2.1P AD=2.1P PS=10.42U
+ PD=10.42U
* device instance $1261 r0 *1 55.015,408.55 pfet
M$1261 x2_n5 x2_n4 VDD_DRV VDD_DRV pfet L=0.55U W=10U AS=2.1P AD=2.1P PS=10.42U
+ PD=10.42U
* device instance $1262 r0 *1 55.985,408.55 pfet
M$1262 VDD_DRV x2_n4 x2_n5 VDD_DRV pfet L=0.55U W=10U AS=2.1P AD=2.1P PS=10.42U
+ PD=10.42U
* device instance $1263 r0 *1 56.955,408.55 pfet
M$1263 x2_n5 x2_n4 VDD_DRV VDD_DRV pfet L=0.55U W=10U AS=2.1P AD=2.1P PS=10.42U
+ PD=10.42U
* device instance $1264 r0 *1 57.925,408.55 pfet
M$1264 VDD_DRV x2_n4 x2_n5 VDD_DRV pfet L=0.55U W=10U AS=2.1P AD=2.1P PS=10.42U
+ PD=10.42U
* device instance $1265 r0 *1 58.895,408.55 pfet
M$1265 x2_n5 x2_n4 VDD_DRV VDD_DRV pfet L=0.55U W=10U AS=2.1P AD=2.1P PS=10.42U
+ PD=10.42U
* device instance $1266 r0 *1 424.585,440.17 pfet
M$1266 VDD_DRV x2_n5 OUT VDD_DRV pfet L=0.55U W=10U AS=2.1P AD=2.1P PS=10.42U
+ PD=10.42U
* device instance $1267 r0 *1 425.555,440.17 pfet
M$1267 OUT x2_n5 VDD_DRV VDD_DRV pfet L=0.55U W=10U AS=2.1P AD=2.1P PS=10.42U
+ PD=10.42U
* device instance $1268 r0 *1 426.525,440.17 pfet
M$1268 VDD_DRV x2_n5 OUT VDD_DRV pfet L=0.55U W=10U AS=2.1P AD=2.1P PS=10.42U
+ PD=10.42U
* device instance $1269 r0 *1 427.495,440.17 pfet
M$1269 OUT x2_n5 VDD_DRV VDD_DRV pfet L=0.55U W=10U AS=2.1P AD=2.1P PS=10.42U
+ PD=10.42U
* device instance $1270 r0 *1 428.465,440.17 pfet
M$1270 VDD_DRV x2_n5 OUT VDD_DRV pfet L=0.55U W=10U AS=2.1P AD=2.1P PS=10.42U
+ PD=10.42U
* device instance $1271 r0 *1 429.435,440.17 pfet
M$1271 OUT x2_n5 VDD_DRV VDD_DRV pfet L=0.55U W=10U AS=2.1P AD=2.1P PS=10.42U
+ PD=10.42U
* device instance $1272 r0 *1 430.405,440.17 pfet
M$1272 VDD_DRV x2_n5 OUT VDD_DRV pfet L=0.55U W=10U AS=2.1P AD=2.1P PS=10.42U
+ PD=10.42U
* device instance $1273 r0 *1 431.375,440.17 pfet
M$1273 OUT x2_n5 VDD_DRV VDD_DRV pfet L=0.55U W=10U AS=2.1P AD=2.1P PS=10.42U
+ PD=10.42U
* device instance $1274 r0 *1 432.345,440.17 pfet
M$1274 VDD_DRV x2_n5 OUT VDD_DRV pfet L=0.55U W=10U AS=2.1P AD=2.1P PS=10.42U
+ PD=10.42U
* device instance $1275 r0 *1 433.315,440.17 pfet
M$1275 OUT x2_n5 VDD_DRV VDD_DRV pfet L=0.55U W=10U AS=2.1P AD=2.1P PS=10.42U
+ PD=10.42U
* device instance $1276 r0 *1 434.285,440.17 pfet
M$1276 VDD_DRV x2_n5 OUT VDD_DRV pfet L=0.55U W=10U AS=2.1P AD=2.1P PS=10.42U
+ PD=10.42U
* device instance $1277 r0 *1 435.255,440.17 pfet
M$1277 OUT x2_n5 VDD_DRV VDD_DRV pfet L=0.55U W=10U AS=2.1P AD=2.1P PS=10.42U
+ PD=10.42U
* device instance $1278 r0 *1 436.225,440.17 pfet
M$1278 VDD_DRV x2_n5 OUT VDD_DRV pfet L=0.55U W=10U AS=2.1P AD=2.1P PS=10.42U
+ PD=10.42U
* device instance $1279 r0 *1 437.195,440.17 pfet
M$1279 OUT x2_n5 VDD_DRV VDD_DRV pfet L=0.55U W=10U AS=2.1P AD=2.1P PS=10.42U
+ PD=10.42U
* device instance $1280 r0 *1 438.165,440.17 pfet
M$1280 VDD_DRV x2_n5 OUT VDD_DRV pfet L=0.55U W=10U AS=2.1P AD=2.1P PS=10.42U
+ PD=10.42U
* device instance $1281 r0 *1 439.135,440.17 pfet
M$1281 OUT x2_n5 VDD_DRV VDD_DRV pfet L=0.55U W=10U AS=2.1P AD=2.1P PS=10.42U
+ PD=10.42U
* device instance $1282 r0 *1 440.105,440.17 pfet
M$1282 VDD_DRV x2_n5 OUT VDD_DRV pfet L=0.55U W=10U AS=2.1P AD=2.1P PS=10.42U
+ PD=10.42U
* device instance $1283 r0 *1 441.075,440.17 pfet
M$1283 OUT x2_n5 VDD_DRV VDD_DRV pfet L=0.55U W=10U AS=2.1P AD=2.1P PS=10.42U
+ PD=10.42U
* device instance $1284 r0 *1 442.045,440.17 pfet
M$1284 VDD_DRV x2_n5 OUT VDD_DRV pfet L=0.55U W=10U AS=2.1P AD=2.1P PS=10.42U
+ PD=10.42U
* device instance $1285 r0 *1 443.015,440.17 pfet
M$1285 OUT x2_n5 VDD_DRV VDD_DRV pfet L=0.55U W=10U AS=2.1P AD=2.1P PS=10.42U
+ PD=10.42U
* device instance $1286 r0 *1 443.985,440.17 pfet
M$1286 VDD_DRV x2_n5 OUT VDD_DRV pfet L=0.55U W=10U AS=2.1P AD=2.1P PS=10.42U
+ PD=10.42U
* device instance $1287 r0 *1 444.955,440.17 pfet
M$1287 OUT x2_n5 VDD_DRV VDD_DRV pfet L=0.55U W=10U AS=2.1P AD=2.1P PS=10.42U
+ PD=10.42U
* device instance $1288 r0 *1 445.925,440.17 pfet
M$1288 VDD_DRV x2_n5 OUT VDD_DRV pfet L=0.55U W=10U AS=2.1P AD=2.1P PS=10.42U
+ PD=10.42U
* device instance $1289 r0 *1 446.895,440.17 pfet
M$1289 OUT x2_n5 VDD_DRV VDD_DRV pfet L=0.55U W=10U AS=2.1P AD=2.1P PS=10.42U
+ PD=10.42U
* device instance $1290 r0 *1 447.865,440.17 pfet
M$1290 VDD_DRV x2_n5 OUT VDD_DRV pfet L=0.55U W=10U AS=2.1P AD=2.1P PS=10.42U
+ PD=10.42U
* device instance $1291 r0 *1 448.835,440.17 pfet
M$1291 OUT x2_n5 VDD_DRV VDD_DRV pfet L=0.55U W=10U AS=2.1P AD=2.1P PS=10.42U
+ PD=10.42U
* device instance $1292 r0 *1 449.805,440.17 pfet
M$1292 VDD_DRV x2_n5 OUT VDD_DRV pfet L=0.55U W=10U AS=2.1P AD=2.1P PS=10.42U
+ PD=10.42U
* device instance $1293 r0 *1 450.775,440.17 pfet
M$1293 OUT x2_n5 VDD_DRV VDD_DRV pfet L=0.55U W=10U AS=2.1P AD=2.1P PS=10.42U
+ PD=10.42U
* device instance $1294 r0 *1 451.745,440.17 pfet
M$1294 VDD_DRV x2_n5 OUT VDD_DRV pfet L=0.55U W=10U AS=2.1P AD=2.1P PS=10.42U
+ PD=10.42U
* device instance $1295 r0 *1 452.715,440.17 pfet
M$1295 OUT x2_n5 VDD_DRV VDD_DRV pfet L=0.55U W=10U AS=2.1P AD=2.1P PS=10.42U
+ PD=10.42U
* device instance $1296 r0 *1 453.685,440.17 pfet
M$1296 VDD_DRV x2_n5 OUT VDD_DRV pfet L=0.55U W=10U AS=2.1P AD=2.1P PS=10.42U
+ PD=10.42U
* device instance $1297 r0 *1 454.655,440.17 pfet
M$1297 OUT x2_n5 VDD_DRV VDD_DRV pfet L=0.55U W=10U AS=2.1P AD=2.1P PS=10.42U
+ PD=10.42U
* device instance $1298 r0 *1 455.625,440.17 pfet
M$1298 VDD_DRV x2_n5 OUT VDD_DRV pfet L=0.55U W=10U AS=2.1P AD=2.1P PS=10.42U
+ PD=10.42U
* device instance $1299 r0 *1 456.595,440.17 pfet
M$1299 OUT x2_n5 VDD_DRV VDD_DRV pfet L=0.55U W=10U AS=2.1P AD=2.1P PS=10.42U
+ PD=10.42U
* device instance $1300 r0 *1 457.565,440.17 pfet
M$1300 VDD_DRV x2_n5 OUT VDD_DRV pfet L=0.55U W=10U AS=2.1P AD=2.1P PS=10.42U
+ PD=10.42U
* device instance $1301 r0 *1 458.535,440.17 pfet
M$1301 OUT x2_n5 VDD_DRV VDD_DRV pfet L=0.55U W=10U AS=2.1P AD=2.1P PS=10.42U
+ PD=10.42U
* device instance $1302 r0 *1 459.505,440.17 pfet
M$1302 VDD_DRV x2_n5 OUT VDD_DRV pfet L=0.55U W=10U AS=2.1P AD=2.1P PS=10.42U
+ PD=10.42U
* device instance $1303 r0 *1 460.475,440.17 pfet
M$1303 OUT x2_n5 VDD_DRV VDD_DRV pfet L=0.55U W=10U AS=2.1P AD=2.1P PS=10.42U
+ PD=10.42U
* device instance $1304 r0 *1 461.445,440.17 pfet
M$1304 VDD_DRV x2_n5 OUT VDD_DRV pfet L=0.55U W=10U AS=2.1P AD=2.1P PS=10.42U
+ PD=10.42U
* device instance $1305 r0 *1 462.415,440.17 pfet
M$1305 OUT x2_n5 VDD_DRV VDD_DRV pfet L=0.55U W=10U AS=2.1P AD=2.1P PS=10.42U
+ PD=10.42U
* device instance $1306 r0 *1 463.385,440.17 pfet
M$1306 VDD_DRV x2_n5 OUT VDD_DRV pfet L=0.55U W=10U AS=2.1P AD=2.1P PS=10.42U
+ PD=10.42U
* device instance $1307 r0 *1 464.355,440.17 pfet
M$1307 OUT x2_n5 VDD_DRV VDD_DRV pfet L=0.55U W=10U AS=2.1P AD=2.1P PS=10.42U
+ PD=10.42U
* device instance $1308 r0 *1 465.325,440.17 pfet
M$1308 VDD_DRV x2_n5 OUT VDD_DRV pfet L=0.55U W=10U AS=2.1P AD=2.1P PS=10.42U
+ PD=10.42U
* device instance $1309 r0 *1 466.295,440.17 pfet
M$1309 OUT x2_n5 VDD_DRV VDD_DRV pfet L=0.55U W=10U AS=2.1P AD=2.1P PS=10.42U
+ PD=10.42U
* device instance $1310 r0 *1 467.265,440.17 pfet
M$1310 VDD_DRV x2_n5 OUT VDD_DRV pfet L=0.55U W=10U AS=2.1P AD=2.1P PS=10.42U
+ PD=10.42U
* device instance $1311 r0 *1 468.235,440.17 pfet
M$1311 OUT x2_n5 VDD_DRV VDD_DRV pfet L=0.55U W=10U AS=2.1P AD=2.1P PS=10.42U
+ PD=10.42U
* device instance $1312 r0 *1 469.205,440.17 pfet
M$1312 VDD_DRV x2_n5 OUT VDD_DRV pfet L=0.55U W=10U AS=2.1P AD=2.1P PS=10.42U
+ PD=10.42U
* device instance $1313 r0 *1 470.175,440.17 pfet
M$1313 OUT x2_n5 VDD_DRV VDD_DRV pfet L=0.55U W=10U AS=2.1P AD=2.1P PS=10.42U
+ PD=10.42U
* device instance $1314 r0 *1 471.145,440.17 pfet
M$1314 VDD_DRV x2_n5 OUT VDD_DRV pfet L=0.55U W=10U AS=2.1P AD=2.1P PS=10.42U
+ PD=10.42U
* device instance $1315 r0 *1 472.115,440.17 pfet
M$1315 OUT x2_n5 VDD_DRV VDD_DRV pfet L=0.55U W=10U AS=2.1P AD=2.1P PS=10.42U
+ PD=10.42U
* device instance $1316 r0 *1 473.085,440.17 pfet
M$1316 VDD_DRV x2_n5 OUT VDD_DRV pfet L=0.55U W=10U AS=2.1P AD=2.1P PS=10.42U
+ PD=10.42U
* device instance $1317 r0 *1 474.055,440.17 pfet
M$1317 OUT x2_n5 VDD_DRV VDD_DRV pfet L=0.55U W=10U AS=2.1P AD=2.1P PS=10.42U
+ PD=10.42U
* device instance $1318 r0 *1 475.025,440.17 pfet
M$1318 VDD_DRV x2_n5 OUT VDD_DRV pfet L=0.55U W=10U AS=2.1P AD=2.1P PS=10.42U
+ PD=10.42U
* device instance $1319 r0 *1 475.995,440.17 pfet
M$1319 OUT x2_n5 VDD_DRV VDD_DRV pfet L=0.55U W=10U AS=2.1P AD=2.1P PS=10.42U
+ PD=10.42U
* device instance $1320 r0 *1 476.965,440.17 pfet
M$1320 VDD_DRV x2_n5 OUT VDD_DRV pfet L=0.55U W=10U AS=2.1P AD=2.1P PS=10.42U
+ PD=10.42U
* device instance $1321 r0 *1 477.935,440.17 pfet
M$1321 OUT x2_n5 VDD_DRV VDD_DRV pfet L=0.55U W=10U AS=2.1P AD=2.1P PS=10.42U
+ PD=10.42U
* device instance $1322 r0 *1 478.905,440.17 pfet
M$1322 VDD_DRV x2_n5 OUT VDD_DRV pfet L=0.55U W=10U AS=2.1P AD=2.1P PS=10.42U
+ PD=10.42U
* device instance $1323 r0 *1 479.875,440.17 pfet
M$1323 OUT x2_n5 VDD_DRV VDD_DRV pfet L=0.55U W=10U AS=2.1P AD=2.1P PS=10.42U
+ PD=10.42U
* device instance $1324 r0 *1 480.845,440.17 pfet
M$1324 VDD_DRV x2_n5 OUT VDD_DRV pfet L=0.55U W=10U AS=2.1P AD=2.1P PS=10.42U
+ PD=10.42U
* device instance $1325 r0 *1 481.815,440.17 pfet
M$1325 OUT x2_n5 VDD_DRV VDD_DRV pfet L=0.55U W=10U AS=2.1P AD=2.1P PS=10.42U
+ PD=10.42U
* device instance $1326 r0 *1 482.785,440.17 pfet
M$1326 VDD_DRV x2_n5 OUT VDD_DRV pfet L=0.55U W=10U AS=2.1P AD=2.1P PS=10.42U
+ PD=10.42U
* device instance $1327 r0 *1 483.755,440.17 pfet
M$1327 OUT x2_n5 VDD_DRV VDD_DRV pfet L=0.55U W=10U AS=2.1P AD=2.1P PS=10.42U
+ PD=10.42U
* device instance $1328 r0 *1 484.725,440.17 pfet
M$1328 VDD_DRV x2_n5 OUT VDD_DRV pfet L=0.55U W=10U AS=2.1P AD=4.2P PS=10.42U
+ PD=20.84U
* device instance $1329 r0 *1 365.415,440.17 pfet
M$1329 OUT x2_n5 VDD_DRV VDD_DRV pfet L=0.55U W=10U AS=2.1P AD=2.1P PS=10.42U
+ PD=10.42U
* device instance $1330 r0 *1 366.385,440.17 pfet
M$1330 VDD_DRV x2_n5 OUT VDD_DRV pfet L=0.55U W=10U AS=2.1P AD=2.1P PS=10.42U
+ PD=10.42U
* device instance $1331 r0 *1 367.355,440.17 pfet
M$1331 OUT x2_n5 VDD_DRV VDD_DRV pfet L=0.55U W=10U AS=2.1P AD=2.1P PS=10.42U
+ PD=10.42U
* device instance $1332 r0 *1 368.325,440.17 pfet
M$1332 VDD_DRV x2_n5 OUT VDD_DRV pfet L=0.55U W=10U AS=2.1P AD=2.1P PS=10.42U
+ PD=10.42U
* device instance $1333 r0 *1 369.295,440.17 pfet
M$1333 OUT x2_n5 VDD_DRV VDD_DRV pfet L=0.55U W=10U AS=2.1P AD=2.1P PS=10.42U
+ PD=10.42U
* device instance $1334 r0 *1 370.265,440.17 pfet
M$1334 VDD_DRV x2_n5 OUT VDD_DRV pfet L=0.55U W=10U AS=2.1P AD=2.1P PS=10.42U
+ PD=10.42U
* device instance $1335 r0 *1 371.235,440.17 pfet
M$1335 OUT x2_n5 VDD_DRV VDD_DRV pfet L=0.55U W=10U AS=2.1P AD=2.1P PS=10.42U
+ PD=10.42U
* device instance $1336 r0 *1 372.205,440.17 pfet
M$1336 VDD_DRV x2_n5 OUT VDD_DRV pfet L=0.55U W=10U AS=2.1P AD=2.1P PS=10.42U
+ PD=10.42U
* device instance $1337 r0 *1 373.175,440.17 pfet
M$1337 OUT x2_n5 VDD_DRV VDD_DRV pfet L=0.55U W=10U AS=2.1P AD=2.1P PS=10.42U
+ PD=10.42U
* device instance $1338 r0 *1 374.145,440.17 pfet
M$1338 VDD_DRV x2_n5 OUT VDD_DRV pfet L=0.55U W=10U AS=2.1P AD=2.1P PS=10.42U
+ PD=10.42U
* device instance $1339 r0 *1 375.115,440.17 pfet
M$1339 OUT x2_n5 VDD_DRV VDD_DRV pfet L=0.55U W=10U AS=2.1P AD=2.1P PS=10.42U
+ PD=10.42U
* device instance $1340 r0 *1 376.085,440.17 pfet
M$1340 VDD_DRV x2_n5 OUT VDD_DRV pfet L=0.55U W=10U AS=2.1P AD=2.1P PS=10.42U
+ PD=10.42U
* device instance $1341 r0 *1 377.055,440.17 pfet
M$1341 OUT x2_n5 VDD_DRV VDD_DRV pfet L=0.55U W=10U AS=2.1P AD=2.1P PS=10.42U
+ PD=10.42U
* device instance $1342 r0 *1 378.025,440.17 pfet
M$1342 VDD_DRV x2_n5 OUT VDD_DRV pfet L=0.55U W=10U AS=2.1P AD=2.1P PS=10.42U
+ PD=10.42U
* device instance $1343 r0 *1 378.995,440.17 pfet
M$1343 OUT x2_n5 VDD_DRV VDD_DRV pfet L=0.55U W=10U AS=2.1P AD=2.1P PS=10.42U
+ PD=10.42U
* device instance $1344 r0 *1 379.965,440.17 pfet
M$1344 VDD_DRV x2_n5 OUT VDD_DRV pfet L=0.55U W=10U AS=2.1P AD=2.1P PS=10.42U
+ PD=10.42U
* device instance $1345 r0 *1 380.935,440.17 pfet
M$1345 OUT x2_n5 VDD_DRV VDD_DRV pfet L=0.55U W=10U AS=2.1P AD=2.1P PS=10.42U
+ PD=10.42U
* device instance $1346 r0 *1 381.905,440.17 pfet
M$1346 VDD_DRV x2_n5 OUT VDD_DRV pfet L=0.55U W=10U AS=2.1P AD=2.1P PS=10.42U
+ PD=10.42U
* device instance $1347 r0 *1 382.875,440.17 pfet
M$1347 OUT x2_n5 VDD_DRV VDD_DRV pfet L=0.55U W=10U AS=2.1P AD=2.1P PS=10.42U
+ PD=10.42U
* device instance $1348 r0 *1 383.845,440.17 pfet
M$1348 VDD_DRV x2_n5 OUT VDD_DRV pfet L=0.55U W=10U AS=2.1P AD=2.1P PS=10.42U
+ PD=10.42U
* device instance $1349 r0 *1 384.815,440.17 pfet
M$1349 OUT x2_n5 VDD_DRV VDD_DRV pfet L=0.55U W=10U AS=2.1P AD=2.1P PS=10.42U
+ PD=10.42U
* device instance $1350 r0 *1 385.785,440.17 pfet
M$1350 VDD_DRV x2_n5 OUT VDD_DRV pfet L=0.55U W=10U AS=2.1P AD=2.1P PS=10.42U
+ PD=10.42U
* device instance $1351 r0 *1 386.755,440.17 pfet
M$1351 OUT x2_n5 VDD_DRV VDD_DRV pfet L=0.55U W=10U AS=2.1P AD=2.1P PS=10.42U
+ PD=10.42U
* device instance $1352 r0 *1 387.725,440.17 pfet
M$1352 VDD_DRV x2_n5 OUT VDD_DRV pfet L=0.55U W=10U AS=2.1P AD=2.1P PS=10.42U
+ PD=10.42U
* device instance $1353 r0 *1 388.695,440.17 pfet
M$1353 OUT x2_n5 VDD_DRV VDD_DRV pfet L=0.55U W=10U AS=2.1P AD=2.1P PS=10.42U
+ PD=10.42U
* device instance $1354 r0 *1 389.665,440.17 pfet
M$1354 VDD_DRV x2_n5 OUT VDD_DRV pfet L=0.55U W=10U AS=2.1P AD=2.1P PS=10.42U
+ PD=10.42U
* device instance $1355 r0 *1 390.635,440.17 pfet
M$1355 OUT x2_n5 VDD_DRV VDD_DRV pfet L=0.55U W=10U AS=2.1P AD=2.1P PS=10.42U
+ PD=10.42U
* device instance $1356 r0 *1 391.605,440.17 pfet
M$1356 VDD_DRV x2_n5 OUT VDD_DRV pfet L=0.55U W=10U AS=2.1P AD=2.1P PS=10.42U
+ PD=10.42U
* device instance $1357 r0 *1 392.575,440.17 pfet
M$1357 OUT x2_n5 VDD_DRV VDD_DRV pfet L=0.55U W=10U AS=2.1P AD=2.1P PS=10.42U
+ PD=10.42U
* device instance $1358 r0 *1 393.545,440.17 pfet
M$1358 VDD_DRV x2_n5 OUT VDD_DRV pfet L=0.55U W=10U AS=2.1P AD=2.1P PS=10.42U
+ PD=10.42U
* device instance $1359 r0 *1 394.515,440.17 pfet
M$1359 OUT x2_n5 VDD_DRV VDD_DRV pfet L=0.55U W=10U AS=2.1P AD=2.1P PS=10.42U
+ PD=10.42U
* device instance $1360 r0 *1 395.485,440.17 pfet
M$1360 VDD_DRV x2_n5 OUT VDD_DRV pfet L=0.55U W=10U AS=2.1P AD=2.1P PS=10.42U
+ PD=10.42U
* device instance $1361 r0 *1 396.455,440.17 pfet
M$1361 OUT x2_n5 VDD_DRV VDD_DRV pfet L=0.55U W=10U AS=2.1P AD=2.1P PS=10.42U
+ PD=10.42U
* device instance $1362 r0 *1 397.425,440.17 pfet
M$1362 VDD_DRV x2_n5 OUT VDD_DRV pfet L=0.55U W=10U AS=2.1P AD=2.1P PS=10.42U
+ PD=10.42U
* device instance $1363 r0 *1 398.395,440.17 pfet
M$1363 OUT x2_n5 VDD_DRV VDD_DRV pfet L=0.55U W=10U AS=2.1P AD=2.1P PS=10.42U
+ PD=10.42U
* device instance $1364 r0 *1 399.365,440.17 pfet
M$1364 VDD_DRV x2_n5 OUT VDD_DRV pfet L=0.55U W=10U AS=2.1P AD=2.1P PS=10.42U
+ PD=10.42U
* device instance $1365 r0 *1 400.335,440.17 pfet
M$1365 OUT x2_n5 VDD_DRV VDD_DRV pfet L=0.55U W=10U AS=2.1P AD=2.1P PS=10.42U
+ PD=10.42U
* device instance $1366 r0 *1 401.305,440.17 pfet
M$1366 VDD_DRV x2_n5 OUT VDD_DRV pfet L=0.55U W=10U AS=2.1P AD=2.1P PS=10.42U
+ PD=10.42U
* device instance $1367 r0 *1 402.275,440.17 pfet
M$1367 OUT x2_n5 VDD_DRV VDD_DRV pfet L=0.55U W=10U AS=2.1P AD=2.1P PS=10.42U
+ PD=10.42U
* device instance $1368 r0 *1 403.245,440.17 pfet
M$1368 VDD_DRV x2_n5 OUT VDD_DRV pfet L=0.55U W=10U AS=2.1P AD=2.1P PS=10.42U
+ PD=10.42U
* device instance $1369 r0 *1 404.215,440.17 pfet
M$1369 OUT x2_n5 VDD_DRV VDD_DRV pfet L=0.55U W=10U AS=2.1P AD=2.1P PS=10.42U
+ PD=10.42U
* device instance $1370 r0 *1 405.185,440.17 pfet
M$1370 VDD_DRV x2_n5 OUT VDD_DRV pfet L=0.55U W=10U AS=2.1P AD=2.1P PS=10.42U
+ PD=10.42U
* device instance $1371 r0 *1 406.155,440.17 pfet
M$1371 OUT x2_n5 VDD_DRV VDD_DRV pfet L=0.55U W=10U AS=2.1P AD=2.1P PS=10.42U
+ PD=10.42U
* device instance $1372 r0 *1 407.125,440.17 pfet
M$1372 VDD_DRV x2_n5 OUT VDD_DRV pfet L=0.55U W=10U AS=2.1P AD=2.1P PS=10.42U
+ PD=10.42U
* device instance $1373 r0 *1 408.095,440.17 pfet
M$1373 OUT x2_n5 VDD_DRV VDD_DRV pfet L=0.55U W=10U AS=2.1P AD=2.1P PS=10.42U
+ PD=10.42U
* device instance $1374 r0 *1 409.065,440.17 pfet
M$1374 VDD_DRV x2_n5 OUT VDD_DRV pfet L=0.55U W=10U AS=2.1P AD=2.1P PS=10.42U
+ PD=10.42U
* device instance $1375 r0 *1 410.035,440.17 pfet
M$1375 OUT x2_n5 VDD_DRV VDD_DRV pfet L=0.55U W=10U AS=2.1P AD=2.1P PS=10.42U
+ PD=10.42U
* device instance $1376 r0 *1 411.005,440.17 pfet
M$1376 VDD_DRV x2_n5 OUT VDD_DRV pfet L=0.55U W=10U AS=2.1P AD=2.1P PS=10.42U
+ PD=10.42U
* device instance $1377 r0 *1 411.975,440.17 pfet
M$1377 OUT x2_n5 VDD_DRV VDD_DRV pfet L=0.55U W=10U AS=2.1P AD=2.1P PS=10.42U
+ PD=10.42U
* device instance $1378 r0 *1 412.945,440.17 pfet
M$1378 VDD_DRV x2_n5 OUT VDD_DRV pfet L=0.55U W=10U AS=2.1P AD=2.1P PS=10.42U
+ PD=10.42U
* device instance $1379 r0 *1 413.915,440.17 pfet
M$1379 OUT x2_n5 VDD_DRV VDD_DRV pfet L=0.55U W=10U AS=2.1P AD=2.1P PS=10.42U
+ PD=10.42U
* device instance $1380 r0 *1 414.885,440.17 pfet
M$1380 VDD_DRV x2_n5 OUT VDD_DRV pfet L=0.55U W=10U AS=2.1P AD=2.1P PS=10.42U
+ PD=10.42U
* device instance $1381 r0 *1 415.855,440.17 pfet
M$1381 OUT x2_n5 VDD_DRV VDD_DRV pfet L=0.55U W=10U AS=2.1P AD=2.1P PS=10.42U
+ PD=10.42U
* device instance $1382 r0 *1 416.825,440.17 pfet
M$1382 VDD_DRV x2_n5 OUT VDD_DRV pfet L=0.55U W=10U AS=2.1P AD=2.1P PS=10.42U
+ PD=10.42U
* device instance $1383 r0 *1 417.795,440.17 pfet
M$1383 OUT x2_n5 VDD_DRV VDD_DRV pfet L=0.55U W=10U AS=2.1P AD=2.1P PS=10.42U
+ PD=10.42U
* device instance $1384 r0 *1 418.765,440.17 pfet
M$1384 VDD_DRV x2_n5 OUT VDD_DRV pfet L=0.55U W=10U AS=2.1P AD=2.1P PS=10.42U
+ PD=10.42U
* device instance $1385 r0 *1 419.735,440.17 pfet
M$1385 OUT x2_n5 VDD_DRV VDD_DRV pfet L=0.55U W=10U AS=2.1P AD=2.1P PS=10.42U
+ PD=10.42U
* device instance $1386 r0 *1 420.705,440.17 pfet
M$1386 VDD_DRV x2_n5 OUT VDD_DRV pfet L=0.55U W=10U AS=2.1P AD=2.1P PS=10.42U
+ PD=10.42U
* device instance $1387 r0 *1 421.675,440.17 pfet
M$1387 OUT x2_n5 VDD_DRV VDD_DRV pfet L=0.55U W=10U AS=2.1P AD=2.1P PS=10.42U
+ PD=10.42U
* device instance $1388 r0 *1 422.645,440.17 pfet
M$1388 VDD_DRV x2_n5 OUT VDD_DRV pfet L=0.55U W=10U AS=2.1P AD=2.1P PS=10.42U
+ PD=10.42U
* device instance $1389 r0 *1 423.615,440.17 pfet
M$1389 OUT x2_n5 VDD_DRV VDD_DRV pfet L=0.55U W=10U AS=2.1P AD=2.1P PS=10.42U
+ PD=10.42U
* device instance $1390 r0 *1 364.445,440.17 pfet
M$1390 VDD_DRV x2_n5 OUT VDD_DRV pfet L=0.55U W=10U AS=2.1P AD=2.1P PS=10.42U
+ PD=10.42U
* device instance $1391 r0 *1 303.335,440.17 pfet
M$1391 OUT x2_n5 VDD_DRV VDD_DRV pfet L=0.55U W=10U AS=2.1P AD=2.1P PS=10.42U
+ PD=10.42U
* device instance $1392 r0 *1 304.305,440.17 pfet
M$1392 VDD_DRV x2_n5 OUT VDD_DRV pfet L=0.55U W=10U AS=2.1P AD=2.1P PS=10.42U
+ PD=10.42U
* device instance $1393 r0 *1 305.275,440.17 pfet
M$1393 OUT x2_n5 VDD_DRV VDD_DRV pfet L=0.55U W=10U AS=2.1P AD=2.1P PS=10.42U
+ PD=10.42U
* device instance $1394 r0 *1 306.245,440.17 pfet
M$1394 VDD_DRV x2_n5 OUT VDD_DRV pfet L=0.55U W=10U AS=2.1P AD=2.1P PS=10.42U
+ PD=10.42U
* device instance $1395 r0 *1 307.215,440.17 pfet
M$1395 OUT x2_n5 VDD_DRV VDD_DRV pfet L=0.55U W=10U AS=2.1P AD=2.1P PS=10.42U
+ PD=10.42U
* device instance $1396 r0 *1 308.185,440.17 pfet
M$1396 VDD_DRV x2_n5 OUT VDD_DRV pfet L=0.55U W=10U AS=2.1P AD=2.1P PS=10.42U
+ PD=10.42U
* device instance $1397 r0 *1 309.155,440.17 pfet
M$1397 OUT x2_n5 VDD_DRV VDD_DRV pfet L=0.55U W=10U AS=2.1P AD=2.1P PS=10.42U
+ PD=10.42U
* device instance $1398 r0 *1 310.125,440.17 pfet
M$1398 VDD_DRV x2_n5 OUT VDD_DRV pfet L=0.55U W=10U AS=2.1P AD=2.1P PS=10.42U
+ PD=10.42U
* device instance $1399 r0 *1 311.095,440.17 pfet
M$1399 OUT x2_n5 VDD_DRV VDD_DRV pfet L=0.55U W=10U AS=2.1P AD=2.1P PS=10.42U
+ PD=10.42U
* device instance $1400 r0 *1 312.065,440.17 pfet
M$1400 VDD_DRV x2_n5 OUT VDD_DRV pfet L=0.55U W=10U AS=2.1P AD=2.1P PS=10.42U
+ PD=10.42U
* device instance $1401 r0 *1 313.035,440.17 pfet
M$1401 OUT x2_n5 VDD_DRV VDD_DRV pfet L=0.55U W=10U AS=2.1P AD=2.1P PS=10.42U
+ PD=10.42U
* device instance $1402 r0 *1 314.005,440.17 pfet
M$1402 VDD_DRV x2_n5 OUT VDD_DRV pfet L=0.55U W=10U AS=2.1P AD=2.1P PS=10.42U
+ PD=10.42U
* device instance $1403 r0 *1 314.975,440.17 pfet
M$1403 OUT x2_n5 VDD_DRV VDD_DRV pfet L=0.55U W=10U AS=2.1P AD=2.1P PS=10.42U
+ PD=10.42U
* device instance $1404 r0 *1 315.945,440.17 pfet
M$1404 VDD_DRV x2_n5 OUT VDD_DRV pfet L=0.55U W=10U AS=2.1P AD=2.1P PS=10.42U
+ PD=10.42U
* device instance $1405 r0 *1 316.915,440.17 pfet
M$1405 OUT x2_n5 VDD_DRV VDD_DRV pfet L=0.55U W=10U AS=2.1P AD=2.1P PS=10.42U
+ PD=10.42U
* device instance $1406 r0 *1 317.885,440.17 pfet
M$1406 VDD_DRV x2_n5 OUT VDD_DRV pfet L=0.55U W=10U AS=2.1P AD=2.1P PS=10.42U
+ PD=10.42U
* device instance $1407 r0 *1 318.855,440.17 pfet
M$1407 OUT x2_n5 VDD_DRV VDD_DRV pfet L=0.55U W=10U AS=2.1P AD=2.1P PS=10.42U
+ PD=10.42U
* device instance $1408 r0 *1 319.825,440.17 pfet
M$1408 VDD_DRV x2_n5 OUT VDD_DRV pfet L=0.55U W=10U AS=2.1P AD=2.1P PS=10.42U
+ PD=10.42U
* device instance $1409 r0 *1 320.795,440.17 pfet
M$1409 OUT x2_n5 VDD_DRV VDD_DRV pfet L=0.55U W=10U AS=2.1P AD=2.1P PS=10.42U
+ PD=10.42U
* device instance $1410 r0 *1 321.765,440.17 pfet
M$1410 VDD_DRV x2_n5 OUT VDD_DRV pfet L=0.55U W=10U AS=2.1P AD=2.1P PS=10.42U
+ PD=10.42U
* device instance $1411 r0 *1 322.735,440.17 pfet
M$1411 OUT x2_n5 VDD_DRV VDD_DRV pfet L=0.55U W=10U AS=2.1P AD=2.1P PS=10.42U
+ PD=10.42U
* device instance $1412 r0 *1 323.705,440.17 pfet
M$1412 VDD_DRV x2_n5 OUT VDD_DRV pfet L=0.55U W=10U AS=2.1P AD=2.1P PS=10.42U
+ PD=10.42U
* device instance $1413 r0 *1 324.675,440.17 pfet
M$1413 OUT x2_n5 VDD_DRV VDD_DRV pfet L=0.55U W=10U AS=2.1P AD=2.1P PS=10.42U
+ PD=10.42U
* device instance $1414 r0 *1 325.645,440.17 pfet
M$1414 VDD_DRV x2_n5 OUT VDD_DRV pfet L=0.55U W=10U AS=2.1P AD=2.1P PS=10.42U
+ PD=10.42U
* device instance $1415 r0 *1 326.615,440.17 pfet
M$1415 OUT x2_n5 VDD_DRV VDD_DRV pfet L=0.55U W=10U AS=2.1P AD=2.1P PS=10.42U
+ PD=10.42U
* device instance $1416 r0 *1 327.585,440.17 pfet
M$1416 VDD_DRV x2_n5 OUT VDD_DRV pfet L=0.55U W=10U AS=2.1P AD=2.1P PS=10.42U
+ PD=10.42U
* device instance $1417 r0 *1 328.555,440.17 pfet
M$1417 OUT x2_n5 VDD_DRV VDD_DRV pfet L=0.55U W=10U AS=2.1P AD=2.1P PS=10.42U
+ PD=10.42U
* device instance $1418 r0 *1 329.525,440.17 pfet
M$1418 VDD_DRV x2_n5 OUT VDD_DRV pfet L=0.55U W=10U AS=2.1P AD=2.1P PS=10.42U
+ PD=10.42U
* device instance $1419 r0 *1 330.495,440.17 pfet
M$1419 OUT x2_n5 VDD_DRV VDD_DRV pfet L=0.55U W=10U AS=2.1P AD=2.1P PS=10.42U
+ PD=10.42U
* device instance $1420 r0 *1 331.465,440.17 pfet
M$1420 VDD_DRV x2_n5 OUT VDD_DRV pfet L=0.55U W=10U AS=2.1P AD=2.1P PS=10.42U
+ PD=10.42U
* device instance $1421 r0 *1 332.435,440.17 pfet
M$1421 OUT x2_n5 VDD_DRV VDD_DRV pfet L=0.55U W=10U AS=2.1P AD=2.1P PS=10.42U
+ PD=10.42U
* device instance $1422 r0 *1 333.405,440.17 pfet
M$1422 VDD_DRV x2_n5 OUT VDD_DRV pfet L=0.55U W=10U AS=2.1P AD=2.1P PS=10.42U
+ PD=10.42U
* device instance $1423 r0 *1 334.375,440.17 pfet
M$1423 OUT x2_n5 VDD_DRV VDD_DRV pfet L=0.55U W=10U AS=2.1P AD=2.1P PS=10.42U
+ PD=10.42U
* device instance $1424 r0 *1 335.345,440.17 pfet
M$1424 VDD_DRV x2_n5 OUT VDD_DRV pfet L=0.55U W=10U AS=2.1P AD=2.1P PS=10.42U
+ PD=10.42U
* device instance $1425 r0 *1 336.315,440.17 pfet
M$1425 OUT x2_n5 VDD_DRV VDD_DRV pfet L=0.55U W=10U AS=2.1P AD=2.1P PS=10.42U
+ PD=10.42U
* device instance $1426 r0 *1 337.285,440.17 pfet
M$1426 VDD_DRV x2_n5 OUT VDD_DRV pfet L=0.55U W=10U AS=2.1P AD=2.1P PS=10.42U
+ PD=10.42U
* device instance $1427 r0 *1 338.255,440.17 pfet
M$1427 OUT x2_n5 VDD_DRV VDD_DRV pfet L=0.55U W=10U AS=2.1P AD=2.1P PS=10.42U
+ PD=10.42U
* device instance $1428 r0 *1 339.225,440.17 pfet
M$1428 VDD_DRV x2_n5 OUT VDD_DRV pfet L=0.55U W=10U AS=2.1P AD=2.1P PS=10.42U
+ PD=10.42U
* device instance $1429 r0 *1 340.195,440.17 pfet
M$1429 OUT x2_n5 VDD_DRV VDD_DRV pfet L=0.55U W=10U AS=2.1P AD=2.1P PS=10.42U
+ PD=10.42U
* device instance $1430 r0 *1 341.165,440.17 pfet
M$1430 VDD_DRV x2_n5 OUT VDD_DRV pfet L=0.55U W=10U AS=2.1P AD=2.1P PS=10.42U
+ PD=10.42U
* device instance $1431 r0 *1 342.135,440.17 pfet
M$1431 OUT x2_n5 VDD_DRV VDD_DRV pfet L=0.55U W=10U AS=2.1P AD=2.1P PS=10.42U
+ PD=10.42U
* device instance $1432 r0 *1 343.105,440.17 pfet
M$1432 VDD_DRV x2_n5 OUT VDD_DRV pfet L=0.55U W=10U AS=2.1P AD=2.1P PS=10.42U
+ PD=10.42U
* device instance $1433 r0 *1 344.075,440.17 pfet
M$1433 OUT x2_n5 VDD_DRV VDD_DRV pfet L=0.55U W=10U AS=2.1P AD=2.1P PS=10.42U
+ PD=10.42U
* device instance $1434 r0 *1 345.045,440.17 pfet
M$1434 VDD_DRV x2_n5 OUT VDD_DRV pfet L=0.55U W=10U AS=2.1P AD=2.1P PS=10.42U
+ PD=10.42U
* device instance $1435 r0 *1 346.015,440.17 pfet
M$1435 OUT x2_n5 VDD_DRV VDD_DRV pfet L=0.55U W=10U AS=2.1P AD=2.1P PS=10.42U
+ PD=10.42U
* device instance $1436 r0 *1 346.985,440.17 pfet
M$1436 VDD_DRV x2_n5 OUT VDD_DRV pfet L=0.55U W=10U AS=2.1P AD=2.1P PS=10.42U
+ PD=10.42U
* device instance $1437 r0 *1 347.955,440.17 pfet
M$1437 OUT x2_n5 VDD_DRV VDD_DRV pfet L=0.55U W=10U AS=2.1P AD=2.1P PS=10.42U
+ PD=10.42U
* device instance $1438 r0 *1 348.925,440.17 pfet
M$1438 VDD_DRV x2_n5 OUT VDD_DRV pfet L=0.55U W=10U AS=2.1P AD=2.1P PS=10.42U
+ PD=10.42U
* device instance $1439 r0 *1 349.895,440.17 pfet
M$1439 OUT x2_n5 VDD_DRV VDD_DRV pfet L=0.55U W=10U AS=2.1P AD=2.1P PS=10.42U
+ PD=10.42U
* device instance $1440 r0 *1 350.865,440.17 pfet
M$1440 VDD_DRV x2_n5 OUT VDD_DRV pfet L=0.55U W=10U AS=2.1P AD=2.1P PS=10.42U
+ PD=10.42U
* device instance $1441 r0 *1 351.835,440.17 pfet
M$1441 OUT x2_n5 VDD_DRV VDD_DRV pfet L=0.55U W=10U AS=2.1P AD=2.1P PS=10.42U
+ PD=10.42U
* device instance $1442 r0 *1 352.805,440.17 pfet
M$1442 VDD_DRV x2_n5 OUT VDD_DRV pfet L=0.55U W=10U AS=2.1P AD=2.1P PS=10.42U
+ PD=10.42U
* device instance $1443 r0 *1 353.775,440.17 pfet
M$1443 OUT x2_n5 VDD_DRV VDD_DRV pfet L=0.55U W=10U AS=2.1P AD=2.1P PS=10.42U
+ PD=10.42U
* device instance $1444 r0 *1 354.745,440.17 pfet
M$1444 VDD_DRV x2_n5 OUT VDD_DRV pfet L=0.55U W=10U AS=2.1P AD=2.1P PS=10.42U
+ PD=10.42U
* device instance $1445 r0 *1 355.715,440.17 pfet
M$1445 OUT x2_n5 VDD_DRV VDD_DRV pfet L=0.55U W=10U AS=2.1P AD=2.1P PS=10.42U
+ PD=10.42U
* device instance $1446 r0 *1 356.685,440.17 pfet
M$1446 VDD_DRV x2_n5 OUT VDD_DRV pfet L=0.55U W=10U AS=2.1P AD=2.1P PS=10.42U
+ PD=10.42U
* device instance $1447 r0 *1 357.655,440.17 pfet
M$1447 OUT x2_n5 VDD_DRV VDD_DRV pfet L=0.55U W=10U AS=2.1P AD=2.1P PS=10.42U
+ PD=10.42U
* device instance $1448 r0 *1 358.625,440.17 pfet
M$1448 VDD_DRV x2_n5 OUT VDD_DRV pfet L=0.55U W=10U AS=2.1P AD=2.1P PS=10.42U
+ PD=10.42U
* device instance $1449 r0 *1 359.595,440.17 pfet
M$1449 OUT x2_n5 VDD_DRV VDD_DRV pfet L=0.55U W=10U AS=2.1P AD=2.1P PS=10.42U
+ PD=10.42U
* device instance $1450 r0 *1 360.565,440.17 pfet
M$1450 VDD_DRV x2_n5 OUT VDD_DRV pfet L=0.55U W=10U AS=2.1P AD=2.1P PS=10.42U
+ PD=10.42U
* device instance $1451 r0 *1 361.535,440.17 pfet
M$1451 OUT x2_n5 VDD_DRV VDD_DRV pfet L=0.55U W=10U AS=2.1P AD=2.1P PS=10.42U
+ PD=10.42U
* device instance $1452 r0 *1 362.505,440.17 pfet
M$1452 VDD_DRV x2_n5 OUT VDD_DRV pfet L=0.55U W=10U AS=2.1P AD=2.1P PS=10.42U
+ PD=10.42U
* device instance $1453 r0 *1 363.475,440.17 pfet
M$1453 OUT x2_n5 VDD_DRV VDD_DRV pfet L=0.55U W=10U AS=2.1P AD=2.1P PS=10.42U
+ PD=10.42U
* device instance $1454 r0 *1 244.165,440.17 pfet
M$1454 VDD_DRV x2_n5 OUT VDD_DRV pfet L=0.55U W=10U AS=2.1P AD=2.1P PS=10.42U
+ PD=10.42U
* device instance $1455 r0 *1 245.135,440.17 pfet
M$1455 OUT x2_n5 VDD_DRV VDD_DRV pfet L=0.55U W=10U AS=2.1P AD=2.1P PS=10.42U
+ PD=10.42U
* device instance $1456 r0 *1 246.105,440.17 pfet
M$1456 VDD_DRV x2_n5 OUT VDD_DRV pfet L=0.55U W=10U AS=2.1P AD=2.1P PS=10.42U
+ PD=10.42U
* device instance $1457 r0 *1 247.075,440.17 pfet
M$1457 OUT x2_n5 VDD_DRV VDD_DRV pfet L=0.55U W=10U AS=2.1P AD=2.1P PS=10.42U
+ PD=10.42U
* device instance $1458 r0 *1 248.045,440.17 pfet
M$1458 VDD_DRV x2_n5 OUT VDD_DRV pfet L=0.55U W=10U AS=2.1P AD=2.1P PS=10.42U
+ PD=10.42U
* device instance $1459 r0 *1 249.015,440.17 pfet
M$1459 OUT x2_n5 VDD_DRV VDD_DRV pfet L=0.55U W=10U AS=2.1P AD=2.1P PS=10.42U
+ PD=10.42U
* device instance $1460 r0 *1 249.985,440.17 pfet
M$1460 VDD_DRV x2_n5 OUT VDD_DRV pfet L=0.55U W=10U AS=2.1P AD=2.1P PS=10.42U
+ PD=10.42U
* device instance $1461 r0 *1 250.955,440.17 pfet
M$1461 OUT x2_n5 VDD_DRV VDD_DRV pfet L=0.55U W=10U AS=2.1P AD=2.1P PS=10.42U
+ PD=10.42U
* device instance $1462 r0 *1 251.925,440.17 pfet
M$1462 VDD_DRV x2_n5 OUT VDD_DRV pfet L=0.55U W=10U AS=2.1P AD=2.1P PS=10.42U
+ PD=10.42U
* device instance $1463 r0 *1 252.895,440.17 pfet
M$1463 OUT x2_n5 VDD_DRV VDD_DRV pfet L=0.55U W=10U AS=2.1P AD=2.1P PS=10.42U
+ PD=10.42U
* device instance $1464 r0 *1 253.865,440.17 pfet
M$1464 VDD_DRV x2_n5 OUT VDD_DRV pfet L=0.55U W=10U AS=2.1P AD=2.1P PS=10.42U
+ PD=10.42U
* device instance $1465 r0 *1 254.835,440.17 pfet
M$1465 OUT x2_n5 VDD_DRV VDD_DRV pfet L=0.55U W=10U AS=2.1P AD=2.1P PS=10.42U
+ PD=10.42U
* device instance $1466 r0 *1 255.805,440.17 pfet
M$1466 VDD_DRV x2_n5 OUT VDD_DRV pfet L=0.55U W=10U AS=2.1P AD=2.1P PS=10.42U
+ PD=10.42U
* device instance $1467 r0 *1 256.775,440.17 pfet
M$1467 OUT x2_n5 VDD_DRV VDD_DRV pfet L=0.55U W=10U AS=2.1P AD=2.1P PS=10.42U
+ PD=10.42U
* device instance $1468 r0 *1 257.745,440.17 pfet
M$1468 VDD_DRV x2_n5 OUT VDD_DRV pfet L=0.55U W=10U AS=2.1P AD=2.1P PS=10.42U
+ PD=10.42U
* device instance $1469 r0 *1 258.715,440.17 pfet
M$1469 OUT x2_n5 VDD_DRV VDD_DRV pfet L=0.55U W=10U AS=2.1P AD=2.1P PS=10.42U
+ PD=10.42U
* device instance $1470 r0 *1 259.685,440.17 pfet
M$1470 VDD_DRV x2_n5 OUT VDD_DRV pfet L=0.55U W=10U AS=2.1P AD=2.1P PS=10.42U
+ PD=10.42U
* device instance $1471 r0 *1 260.655,440.17 pfet
M$1471 OUT x2_n5 VDD_DRV VDD_DRV pfet L=0.55U W=10U AS=2.1P AD=2.1P PS=10.42U
+ PD=10.42U
* device instance $1472 r0 *1 261.625,440.17 pfet
M$1472 VDD_DRV x2_n5 OUT VDD_DRV pfet L=0.55U W=10U AS=2.1P AD=2.1P PS=10.42U
+ PD=10.42U
* device instance $1473 r0 *1 262.595,440.17 pfet
M$1473 OUT x2_n5 VDD_DRV VDD_DRV pfet L=0.55U W=10U AS=2.1P AD=2.1P PS=10.42U
+ PD=10.42U
* device instance $1474 r0 *1 263.565,440.17 pfet
M$1474 VDD_DRV x2_n5 OUT VDD_DRV pfet L=0.55U W=10U AS=2.1P AD=2.1P PS=10.42U
+ PD=10.42U
* device instance $1475 r0 *1 264.535,440.17 pfet
M$1475 OUT x2_n5 VDD_DRV VDD_DRV pfet L=0.55U W=10U AS=2.1P AD=2.1P PS=10.42U
+ PD=10.42U
* device instance $1476 r0 *1 265.505,440.17 pfet
M$1476 VDD_DRV x2_n5 OUT VDD_DRV pfet L=0.55U W=10U AS=2.1P AD=2.1P PS=10.42U
+ PD=10.42U
* device instance $1477 r0 *1 266.475,440.17 pfet
M$1477 OUT x2_n5 VDD_DRV VDD_DRV pfet L=0.55U W=10U AS=2.1P AD=2.1P PS=10.42U
+ PD=10.42U
* device instance $1478 r0 *1 267.445,440.17 pfet
M$1478 VDD_DRV x2_n5 OUT VDD_DRV pfet L=0.55U W=10U AS=2.1P AD=2.1P PS=10.42U
+ PD=10.42U
* device instance $1479 r0 *1 268.415,440.17 pfet
M$1479 OUT x2_n5 VDD_DRV VDD_DRV pfet L=0.55U W=10U AS=2.1P AD=2.1P PS=10.42U
+ PD=10.42U
* device instance $1480 r0 *1 269.385,440.17 pfet
M$1480 VDD_DRV x2_n5 OUT VDD_DRV pfet L=0.55U W=10U AS=2.1P AD=2.1P PS=10.42U
+ PD=10.42U
* device instance $1481 r0 *1 270.355,440.17 pfet
M$1481 OUT x2_n5 VDD_DRV VDD_DRV pfet L=0.55U W=10U AS=2.1P AD=2.1P PS=10.42U
+ PD=10.42U
* device instance $1482 r0 *1 271.325,440.17 pfet
M$1482 VDD_DRV x2_n5 OUT VDD_DRV pfet L=0.55U W=10U AS=2.1P AD=2.1P PS=10.42U
+ PD=10.42U
* device instance $1483 r0 *1 272.295,440.17 pfet
M$1483 OUT x2_n5 VDD_DRV VDD_DRV pfet L=0.55U W=10U AS=2.1P AD=2.1P PS=10.42U
+ PD=10.42U
* device instance $1484 r0 *1 273.265,440.17 pfet
M$1484 VDD_DRV x2_n5 OUT VDD_DRV pfet L=0.55U W=10U AS=2.1P AD=2.1P PS=10.42U
+ PD=10.42U
* device instance $1485 r0 *1 274.235,440.17 pfet
M$1485 OUT x2_n5 VDD_DRV VDD_DRV pfet L=0.55U W=10U AS=2.1P AD=2.1P PS=10.42U
+ PD=10.42U
* device instance $1486 r0 *1 275.205,440.17 pfet
M$1486 VDD_DRV x2_n5 OUT VDD_DRV pfet L=0.55U W=10U AS=2.1P AD=2.1P PS=10.42U
+ PD=10.42U
* device instance $1487 r0 *1 276.175,440.17 pfet
M$1487 OUT x2_n5 VDD_DRV VDD_DRV pfet L=0.55U W=10U AS=2.1P AD=2.1P PS=10.42U
+ PD=10.42U
* device instance $1488 r0 *1 277.145,440.17 pfet
M$1488 VDD_DRV x2_n5 OUT VDD_DRV pfet L=0.55U W=10U AS=2.1P AD=2.1P PS=10.42U
+ PD=10.42U
* device instance $1489 r0 *1 278.115,440.17 pfet
M$1489 OUT x2_n5 VDD_DRV VDD_DRV pfet L=0.55U W=10U AS=2.1P AD=2.1P PS=10.42U
+ PD=10.42U
* device instance $1490 r0 *1 279.085,440.17 pfet
M$1490 VDD_DRV x2_n5 OUT VDD_DRV pfet L=0.55U W=10U AS=2.1P AD=2.1P PS=10.42U
+ PD=10.42U
* device instance $1491 r0 *1 280.055,440.17 pfet
M$1491 OUT x2_n5 VDD_DRV VDD_DRV pfet L=0.55U W=10U AS=2.1P AD=2.1P PS=10.42U
+ PD=10.42U
* device instance $1492 r0 *1 281.025,440.17 pfet
M$1492 VDD_DRV x2_n5 OUT VDD_DRV pfet L=0.55U W=10U AS=2.1P AD=2.1P PS=10.42U
+ PD=10.42U
* device instance $1493 r0 *1 281.995,440.17 pfet
M$1493 OUT x2_n5 VDD_DRV VDD_DRV pfet L=0.55U W=10U AS=2.1P AD=2.1P PS=10.42U
+ PD=10.42U
* device instance $1494 r0 *1 282.965,440.17 pfet
M$1494 VDD_DRV x2_n5 OUT VDD_DRV pfet L=0.55U W=10U AS=2.1P AD=2.1P PS=10.42U
+ PD=10.42U
* device instance $1495 r0 *1 283.935,440.17 pfet
M$1495 OUT x2_n5 VDD_DRV VDD_DRV pfet L=0.55U W=10U AS=2.1P AD=2.1P PS=10.42U
+ PD=10.42U
* device instance $1496 r0 *1 284.905,440.17 pfet
M$1496 VDD_DRV x2_n5 OUT VDD_DRV pfet L=0.55U W=10U AS=2.1P AD=2.1P PS=10.42U
+ PD=10.42U
* device instance $1497 r0 *1 285.875,440.17 pfet
M$1497 OUT x2_n5 VDD_DRV VDD_DRV pfet L=0.55U W=10U AS=2.1P AD=2.1P PS=10.42U
+ PD=10.42U
* device instance $1498 r0 *1 286.845,440.17 pfet
M$1498 VDD_DRV x2_n5 OUT VDD_DRV pfet L=0.55U W=10U AS=2.1P AD=2.1P PS=10.42U
+ PD=10.42U
* device instance $1499 r0 *1 287.815,440.17 pfet
M$1499 OUT x2_n5 VDD_DRV VDD_DRV pfet L=0.55U W=10U AS=2.1P AD=2.1P PS=10.42U
+ PD=10.42U
* device instance $1500 r0 *1 288.785,440.17 pfet
M$1500 VDD_DRV x2_n5 OUT VDD_DRV pfet L=0.55U W=10U AS=2.1P AD=2.1P PS=10.42U
+ PD=10.42U
* device instance $1501 r0 *1 289.755,440.17 pfet
M$1501 OUT x2_n5 VDD_DRV VDD_DRV pfet L=0.55U W=10U AS=2.1P AD=2.1P PS=10.42U
+ PD=10.42U
* device instance $1502 r0 *1 290.725,440.17 pfet
M$1502 VDD_DRV x2_n5 OUT VDD_DRV pfet L=0.55U W=10U AS=2.1P AD=2.1P PS=10.42U
+ PD=10.42U
* device instance $1503 r0 *1 291.695,440.17 pfet
M$1503 OUT x2_n5 VDD_DRV VDD_DRV pfet L=0.55U W=10U AS=2.1P AD=2.1P PS=10.42U
+ PD=10.42U
* device instance $1504 r0 *1 292.665,440.17 pfet
M$1504 VDD_DRV x2_n5 OUT VDD_DRV pfet L=0.55U W=10U AS=2.1P AD=2.1P PS=10.42U
+ PD=10.42U
* device instance $1505 r0 *1 293.635,440.17 pfet
M$1505 OUT x2_n5 VDD_DRV VDD_DRV pfet L=0.55U W=10U AS=2.1P AD=2.1P PS=10.42U
+ PD=10.42U
* device instance $1506 r0 *1 294.605,440.17 pfet
M$1506 VDD_DRV x2_n5 OUT VDD_DRV pfet L=0.55U W=10U AS=2.1P AD=2.1P PS=10.42U
+ PD=10.42U
* device instance $1507 r0 *1 295.575,440.17 pfet
M$1507 OUT x2_n5 VDD_DRV VDD_DRV pfet L=0.55U W=10U AS=2.1P AD=2.1P PS=10.42U
+ PD=10.42U
* device instance $1508 r0 *1 296.545,440.17 pfet
M$1508 VDD_DRV x2_n5 OUT VDD_DRV pfet L=0.55U W=10U AS=2.1P AD=2.1P PS=10.42U
+ PD=10.42U
* device instance $1509 r0 *1 297.515,440.17 pfet
M$1509 OUT x2_n5 VDD_DRV VDD_DRV pfet L=0.55U W=10U AS=2.1P AD=2.1P PS=10.42U
+ PD=10.42U
* device instance $1510 r0 *1 298.485,440.17 pfet
M$1510 VDD_DRV x2_n5 OUT VDD_DRV pfet L=0.55U W=10U AS=2.1P AD=2.1P PS=10.42U
+ PD=10.42U
* device instance $1511 r0 *1 299.455,440.17 pfet
M$1511 OUT x2_n5 VDD_DRV VDD_DRV pfet L=0.55U W=10U AS=2.1P AD=2.1P PS=10.42U
+ PD=10.42U
* device instance $1512 r0 *1 300.425,440.17 pfet
M$1512 VDD_DRV x2_n5 OUT VDD_DRV pfet L=0.55U W=10U AS=2.1P AD=2.1P PS=10.42U
+ PD=10.42U
* device instance $1513 r0 *1 301.395,440.17 pfet
M$1513 OUT x2_n5 VDD_DRV VDD_DRV pfet L=0.55U W=10U AS=2.1P AD=2.1P PS=10.42U
+ PD=10.42U
* device instance $1514 r0 *1 302.365,440.17 pfet
M$1514 VDD_DRV x2_n5 OUT VDD_DRV pfet L=0.55U W=10U AS=2.1P AD=2.1P PS=10.42U
+ PD=10.42U
* device instance $1515 r0 *1 243.195,440.17 pfet
M$1515 OUT x2_n5 VDD_DRV VDD_DRV pfet L=0.55U W=10U AS=2.1P AD=2.1P PS=10.42U
+ PD=10.42U
* device instance $1516 r0 *1 182.085,440.17 pfet
M$1516 VDD_DRV x2_n5 OUT VDD_DRV pfet L=0.55U W=10U AS=2.1P AD=2.1P PS=10.42U
+ PD=10.42U
* device instance $1517 r0 *1 183.055,440.17 pfet
M$1517 OUT x2_n5 VDD_DRV VDD_DRV pfet L=0.55U W=10U AS=2.1P AD=2.1P PS=10.42U
+ PD=10.42U
* device instance $1518 r0 *1 184.025,440.17 pfet
M$1518 VDD_DRV x2_n5 OUT VDD_DRV pfet L=0.55U W=10U AS=2.1P AD=2.1P PS=10.42U
+ PD=10.42U
* device instance $1519 r0 *1 184.995,440.17 pfet
M$1519 OUT x2_n5 VDD_DRV VDD_DRV pfet L=0.55U W=10U AS=2.1P AD=2.1P PS=10.42U
+ PD=10.42U
* device instance $1520 r0 *1 185.965,440.17 pfet
M$1520 VDD_DRV x2_n5 OUT VDD_DRV pfet L=0.55U W=10U AS=2.1P AD=2.1P PS=10.42U
+ PD=10.42U
* device instance $1521 r0 *1 186.935,440.17 pfet
M$1521 OUT x2_n5 VDD_DRV VDD_DRV pfet L=0.55U W=10U AS=2.1P AD=2.1P PS=10.42U
+ PD=10.42U
* device instance $1522 r0 *1 187.905,440.17 pfet
M$1522 VDD_DRV x2_n5 OUT VDD_DRV pfet L=0.55U W=10U AS=2.1P AD=2.1P PS=10.42U
+ PD=10.42U
* device instance $1523 r0 *1 188.875,440.17 pfet
M$1523 OUT x2_n5 VDD_DRV VDD_DRV pfet L=0.55U W=10U AS=2.1P AD=2.1P PS=10.42U
+ PD=10.42U
* device instance $1524 r0 *1 189.845,440.17 pfet
M$1524 VDD_DRV x2_n5 OUT VDD_DRV pfet L=0.55U W=10U AS=2.1P AD=2.1P PS=10.42U
+ PD=10.42U
* device instance $1525 r0 *1 190.815,440.17 pfet
M$1525 OUT x2_n5 VDD_DRV VDD_DRV pfet L=0.55U W=10U AS=2.1P AD=2.1P PS=10.42U
+ PD=10.42U
* device instance $1526 r0 *1 191.785,440.17 pfet
M$1526 VDD_DRV x2_n5 OUT VDD_DRV pfet L=0.55U W=10U AS=2.1P AD=2.1P PS=10.42U
+ PD=10.42U
* device instance $1527 r0 *1 192.755,440.17 pfet
M$1527 OUT x2_n5 VDD_DRV VDD_DRV pfet L=0.55U W=10U AS=2.1P AD=2.1P PS=10.42U
+ PD=10.42U
* device instance $1528 r0 *1 193.725,440.17 pfet
M$1528 VDD_DRV x2_n5 OUT VDD_DRV pfet L=0.55U W=10U AS=2.1P AD=2.1P PS=10.42U
+ PD=10.42U
* device instance $1529 r0 *1 194.695,440.17 pfet
M$1529 OUT x2_n5 VDD_DRV VDD_DRV pfet L=0.55U W=10U AS=2.1P AD=2.1P PS=10.42U
+ PD=10.42U
* device instance $1530 r0 *1 195.665,440.17 pfet
M$1530 VDD_DRV x2_n5 OUT VDD_DRV pfet L=0.55U W=10U AS=2.1P AD=2.1P PS=10.42U
+ PD=10.42U
* device instance $1531 r0 *1 196.635,440.17 pfet
M$1531 OUT x2_n5 VDD_DRV VDD_DRV pfet L=0.55U W=10U AS=2.1P AD=2.1P PS=10.42U
+ PD=10.42U
* device instance $1532 r0 *1 197.605,440.17 pfet
M$1532 VDD_DRV x2_n5 OUT VDD_DRV pfet L=0.55U W=10U AS=2.1P AD=2.1P PS=10.42U
+ PD=10.42U
* device instance $1533 r0 *1 198.575,440.17 pfet
M$1533 OUT x2_n5 VDD_DRV VDD_DRV pfet L=0.55U W=10U AS=2.1P AD=2.1P PS=10.42U
+ PD=10.42U
* device instance $1534 r0 *1 199.545,440.17 pfet
M$1534 VDD_DRV x2_n5 OUT VDD_DRV pfet L=0.55U W=10U AS=2.1P AD=2.1P PS=10.42U
+ PD=10.42U
* device instance $1535 r0 *1 200.515,440.17 pfet
M$1535 OUT x2_n5 VDD_DRV VDD_DRV pfet L=0.55U W=10U AS=2.1P AD=2.1P PS=10.42U
+ PD=10.42U
* device instance $1536 r0 *1 201.485,440.17 pfet
M$1536 VDD_DRV x2_n5 OUT VDD_DRV pfet L=0.55U W=10U AS=2.1P AD=2.1P PS=10.42U
+ PD=10.42U
* device instance $1537 r0 *1 202.455,440.17 pfet
M$1537 OUT x2_n5 VDD_DRV VDD_DRV pfet L=0.55U W=10U AS=2.1P AD=2.1P PS=10.42U
+ PD=10.42U
* device instance $1538 r0 *1 203.425,440.17 pfet
M$1538 VDD_DRV x2_n5 OUT VDD_DRV pfet L=0.55U W=10U AS=2.1P AD=2.1P PS=10.42U
+ PD=10.42U
* device instance $1539 r0 *1 204.395,440.17 pfet
M$1539 OUT x2_n5 VDD_DRV VDD_DRV pfet L=0.55U W=10U AS=2.1P AD=2.1P PS=10.42U
+ PD=10.42U
* device instance $1540 r0 *1 205.365,440.17 pfet
M$1540 VDD_DRV x2_n5 OUT VDD_DRV pfet L=0.55U W=10U AS=2.1P AD=2.1P PS=10.42U
+ PD=10.42U
* device instance $1541 r0 *1 206.335,440.17 pfet
M$1541 OUT x2_n5 VDD_DRV VDD_DRV pfet L=0.55U W=10U AS=2.1P AD=2.1P PS=10.42U
+ PD=10.42U
* device instance $1542 r0 *1 207.305,440.17 pfet
M$1542 VDD_DRV x2_n5 OUT VDD_DRV pfet L=0.55U W=10U AS=2.1P AD=2.1P PS=10.42U
+ PD=10.42U
* device instance $1543 r0 *1 208.275,440.17 pfet
M$1543 OUT x2_n5 VDD_DRV VDD_DRV pfet L=0.55U W=10U AS=2.1P AD=2.1P PS=10.42U
+ PD=10.42U
* device instance $1544 r0 *1 209.245,440.17 pfet
M$1544 VDD_DRV x2_n5 OUT VDD_DRV pfet L=0.55U W=10U AS=2.1P AD=2.1P PS=10.42U
+ PD=10.42U
* device instance $1545 r0 *1 210.215,440.17 pfet
M$1545 OUT x2_n5 VDD_DRV VDD_DRV pfet L=0.55U W=10U AS=2.1P AD=2.1P PS=10.42U
+ PD=10.42U
* device instance $1546 r0 *1 211.185,440.17 pfet
M$1546 VDD_DRV x2_n5 OUT VDD_DRV pfet L=0.55U W=10U AS=2.1P AD=2.1P PS=10.42U
+ PD=10.42U
* device instance $1547 r0 *1 212.155,440.17 pfet
M$1547 OUT x2_n5 VDD_DRV VDD_DRV pfet L=0.55U W=10U AS=2.1P AD=2.1P PS=10.42U
+ PD=10.42U
* device instance $1548 r0 *1 213.125,440.17 pfet
M$1548 VDD_DRV x2_n5 OUT VDD_DRV pfet L=0.55U W=10U AS=2.1P AD=2.1P PS=10.42U
+ PD=10.42U
* device instance $1549 r0 *1 214.095,440.17 pfet
M$1549 OUT x2_n5 VDD_DRV VDD_DRV pfet L=0.55U W=10U AS=2.1P AD=2.1P PS=10.42U
+ PD=10.42U
* device instance $1550 r0 *1 215.065,440.17 pfet
M$1550 VDD_DRV x2_n5 OUT VDD_DRV pfet L=0.55U W=10U AS=2.1P AD=2.1P PS=10.42U
+ PD=10.42U
* device instance $1551 r0 *1 216.035,440.17 pfet
M$1551 OUT x2_n5 VDD_DRV VDD_DRV pfet L=0.55U W=10U AS=2.1P AD=2.1P PS=10.42U
+ PD=10.42U
* device instance $1552 r0 *1 217.005,440.17 pfet
M$1552 VDD_DRV x2_n5 OUT VDD_DRV pfet L=0.55U W=10U AS=2.1P AD=2.1P PS=10.42U
+ PD=10.42U
* device instance $1553 r0 *1 217.975,440.17 pfet
M$1553 OUT x2_n5 VDD_DRV VDD_DRV pfet L=0.55U W=10U AS=2.1P AD=2.1P PS=10.42U
+ PD=10.42U
* device instance $1554 r0 *1 218.945,440.17 pfet
M$1554 VDD_DRV x2_n5 OUT VDD_DRV pfet L=0.55U W=10U AS=2.1P AD=2.1P PS=10.42U
+ PD=10.42U
* device instance $1555 r0 *1 219.915,440.17 pfet
M$1555 OUT x2_n5 VDD_DRV VDD_DRV pfet L=0.55U W=10U AS=2.1P AD=2.1P PS=10.42U
+ PD=10.42U
* device instance $1556 r0 *1 220.885,440.17 pfet
M$1556 VDD_DRV x2_n5 OUT VDD_DRV pfet L=0.55U W=10U AS=2.1P AD=2.1P PS=10.42U
+ PD=10.42U
* device instance $1557 r0 *1 221.855,440.17 pfet
M$1557 OUT x2_n5 VDD_DRV VDD_DRV pfet L=0.55U W=10U AS=2.1P AD=2.1P PS=10.42U
+ PD=10.42U
* device instance $1558 r0 *1 222.825,440.17 pfet
M$1558 VDD_DRV x2_n5 OUT VDD_DRV pfet L=0.55U W=10U AS=2.1P AD=2.1P PS=10.42U
+ PD=10.42U
* device instance $1559 r0 *1 223.795,440.17 pfet
M$1559 OUT x2_n5 VDD_DRV VDD_DRV pfet L=0.55U W=10U AS=2.1P AD=2.1P PS=10.42U
+ PD=10.42U
* device instance $1560 r0 *1 224.765,440.17 pfet
M$1560 VDD_DRV x2_n5 OUT VDD_DRV pfet L=0.55U W=10U AS=2.1P AD=2.1P PS=10.42U
+ PD=10.42U
* device instance $1561 r0 *1 225.735,440.17 pfet
M$1561 OUT x2_n5 VDD_DRV VDD_DRV pfet L=0.55U W=10U AS=2.1P AD=2.1P PS=10.42U
+ PD=10.42U
* device instance $1562 r0 *1 226.705,440.17 pfet
M$1562 VDD_DRV x2_n5 OUT VDD_DRV pfet L=0.55U W=10U AS=2.1P AD=2.1P PS=10.42U
+ PD=10.42U
* device instance $1563 r0 *1 227.675,440.17 pfet
M$1563 OUT x2_n5 VDD_DRV VDD_DRV pfet L=0.55U W=10U AS=2.1P AD=2.1P PS=10.42U
+ PD=10.42U
* device instance $1564 r0 *1 228.645,440.17 pfet
M$1564 VDD_DRV x2_n5 OUT VDD_DRV pfet L=0.55U W=10U AS=2.1P AD=2.1P PS=10.42U
+ PD=10.42U
* device instance $1565 r0 *1 229.615,440.17 pfet
M$1565 OUT x2_n5 VDD_DRV VDD_DRV pfet L=0.55U W=10U AS=2.1P AD=2.1P PS=10.42U
+ PD=10.42U
* device instance $1566 r0 *1 230.585,440.17 pfet
M$1566 VDD_DRV x2_n5 OUT VDD_DRV pfet L=0.55U W=10U AS=2.1P AD=2.1P PS=10.42U
+ PD=10.42U
* device instance $1567 r0 *1 231.555,440.17 pfet
M$1567 OUT x2_n5 VDD_DRV VDD_DRV pfet L=0.55U W=10U AS=2.1P AD=2.1P PS=10.42U
+ PD=10.42U
* device instance $1568 r0 *1 232.525,440.17 pfet
M$1568 VDD_DRV x2_n5 OUT VDD_DRV pfet L=0.55U W=10U AS=2.1P AD=2.1P PS=10.42U
+ PD=10.42U
* device instance $1569 r0 *1 233.495,440.17 pfet
M$1569 OUT x2_n5 VDD_DRV VDD_DRV pfet L=0.55U W=10U AS=2.1P AD=2.1P PS=10.42U
+ PD=10.42U
* device instance $1570 r0 *1 234.465,440.17 pfet
M$1570 VDD_DRV x2_n5 OUT VDD_DRV pfet L=0.55U W=10U AS=2.1P AD=2.1P PS=10.42U
+ PD=10.42U
* device instance $1571 r0 *1 235.435,440.17 pfet
M$1571 OUT x2_n5 VDD_DRV VDD_DRV pfet L=0.55U W=10U AS=2.1P AD=2.1P PS=10.42U
+ PD=10.42U
* device instance $1572 r0 *1 236.405,440.17 pfet
M$1572 VDD_DRV x2_n5 OUT VDD_DRV pfet L=0.55U W=10U AS=2.1P AD=2.1P PS=10.42U
+ PD=10.42U
* device instance $1573 r0 *1 237.375,440.17 pfet
M$1573 OUT x2_n5 VDD_DRV VDD_DRV pfet L=0.55U W=10U AS=2.1P AD=2.1P PS=10.42U
+ PD=10.42U
* device instance $1574 r0 *1 238.345,440.17 pfet
M$1574 VDD_DRV x2_n5 OUT VDD_DRV pfet L=0.55U W=10U AS=2.1P AD=2.1P PS=10.42U
+ PD=10.42U
* device instance $1575 r0 *1 239.315,440.17 pfet
M$1575 OUT x2_n5 VDD_DRV VDD_DRV pfet L=0.55U W=10U AS=2.1P AD=2.1P PS=10.42U
+ PD=10.42U
* device instance $1576 r0 *1 240.285,440.17 pfet
M$1576 VDD_DRV x2_n5 OUT VDD_DRV pfet L=0.55U W=10U AS=2.1P AD=2.1P PS=10.42U
+ PD=10.42U
* device instance $1577 r0 *1 241.255,440.17 pfet
M$1577 OUT x2_n5 VDD_DRV VDD_DRV pfet L=0.55U W=10U AS=2.1P AD=2.1P PS=10.42U
+ PD=10.42U
* device instance $1578 r0 *1 242.225,440.17 pfet
M$1578 VDD_DRV x2_n5 OUT VDD_DRV pfet L=0.55U W=10U AS=2.1P AD=2.1P PS=10.42U
+ PD=10.42U
* device instance $1579 r0 *1 122.915,440.17 pfet
M$1579 OUT x2_n5 VDD_DRV VDD_DRV pfet L=0.55U W=10U AS=2.1P AD=2.1P PS=10.42U
+ PD=10.42U
* device instance $1580 r0 *1 123.885,440.17 pfet
M$1580 VDD_DRV x2_n5 OUT VDD_DRV pfet L=0.55U W=10U AS=2.1P AD=2.1P PS=10.42U
+ PD=10.42U
* device instance $1581 r0 *1 124.855,440.17 pfet
M$1581 OUT x2_n5 VDD_DRV VDD_DRV pfet L=0.55U W=10U AS=2.1P AD=2.1P PS=10.42U
+ PD=10.42U
* device instance $1582 r0 *1 125.825,440.17 pfet
M$1582 VDD_DRV x2_n5 OUT VDD_DRV pfet L=0.55U W=10U AS=2.1P AD=2.1P PS=10.42U
+ PD=10.42U
* device instance $1583 r0 *1 126.795,440.17 pfet
M$1583 OUT x2_n5 VDD_DRV VDD_DRV pfet L=0.55U W=10U AS=2.1P AD=2.1P PS=10.42U
+ PD=10.42U
* device instance $1584 r0 *1 127.765,440.17 pfet
M$1584 VDD_DRV x2_n5 OUT VDD_DRV pfet L=0.55U W=10U AS=2.1P AD=2.1P PS=10.42U
+ PD=10.42U
* device instance $1585 r0 *1 128.735,440.17 pfet
M$1585 OUT x2_n5 VDD_DRV VDD_DRV pfet L=0.55U W=10U AS=2.1P AD=2.1P PS=10.42U
+ PD=10.42U
* device instance $1586 r0 *1 129.705,440.17 pfet
M$1586 VDD_DRV x2_n5 OUT VDD_DRV pfet L=0.55U W=10U AS=2.1P AD=2.1P PS=10.42U
+ PD=10.42U
* device instance $1587 r0 *1 130.675,440.17 pfet
M$1587 OUT x2_n5 VDD_DRV VDD_DRV pfet L=0.55U W=10U AS=2.1P AD=2.1P PS=10.42U
+ PD=10.42U
* device instance $1588 r0 *1 131.645,440.17 pfet
M$1588 VDD_DRV x2_n5 OUT VDD_DRV pfet L=0.55U W=10U AS=2.1P AD=2.1P PS=10.42U
+ PD=10.42U
* device instance $1589 r0 *1 132.615,440.17 pfet
M$1589 OUT x2_n5 VDD_DRV VDD_DRV pfet L=0.55U W=10U AS=2.1P AD=2.1P PS=10.42U
+ PD=10.42U
* device instance $1590 r0 *1 133.585,440.17 pfet
M$1590 VDD_DRV x2_n5 OUT VDD_DRV pfet L=0.55U W=10U AS=2.1P AD=2.1P PS=10.42U
+ PD=10.42U
* device instance $1591 r0 *1 134.555,440.17 pfet
M$1591 OUT x2_n5 VDD_DRV VDD_DRV pfet L=0.55U W=10U AS=2.1P AD=2.1P PS=10.42U
+ PD=10.42U
* device instance $1592 r0 *1 135.525,440.17 pfet
M$1592 VDD_DRV x2_n5 OUT VDD_DRV pfet L=0.55U W=10U AS=2.1P AD=2.1P PS=10.42U
+ PD=10.42U
* device instance $1593 r0 *1 136.495,440.17 pfet
M$1593 OUT x2_n5 VDD_DRV VDD_DRV pfet L=0.55U W=10U AS=2.1P AD=2.1P PS=10.42U
+ PD=10.42U
* device instance $1594 r0 *1 137.465,440.17 pfet
M$1594 VDD_DRV x2_n5 OUT VDD_DRV pfet L=0.55U W=10U AS=2.1P AD=2.1P PS=10.42U
+ PD=10.42U
* device instance $1595 r0 *1 138.435,440.17 pfet
M$1595 OUT x2_n5 VDD_DRV VDD_DRV pfet L=0.55U W=10U AS=2.1P AD=2.1P PS=10.42U
+ PD=10.42U
* device instance $1596 r0 *1 139.405,440.17 pfet
M$1596 VDD_DRV x2_n5 OUT VDD_DRV pfet L=0.55U W=10U AS=2.1P AD=2.1P PS=10.42U
+ PD=10.42U
* device instance $1597 r0 *1 140.375,440.17 pfet
M$1597 OUT x2_n5 VDD_DRV VDD_DRV pfet L=0.55U W=10U AS=2.1P AD=2.1P PS=10.42U
+ PD=10.42U
* device instance $1598 r0 *1 141.345,440.17 pfet
M$1598 VDD_DRV x2_n5 OUT VDD_DRV pfet L=0.55U W=10U AS=2.1P AD=2.1P PS=10.42U
+ PD=10.42U
* device instance $1599 r0 *1 142.315,440.17 pfet
M$1599 OUT x2_n5 VDD_DRV VDD_DRV pfet L=0.55U W=10U AS=2.1P AD=2.1P PS=10.42U
+ PD=10.42U
* device instance $1600 r0 *1 143.285,440.17 pfet
M$1600 VDD_DRV x2_n5 OUT VDD_DRV pfet L=0.55U W=10U AS=2.1P AD=2.1P PS=10.42U
+ PD=10.42U
* device instance $1601 r0 *1 144.255,440.17 pfet
M$1601 OUT x2_n5 VDD_DRV VDD_DRV pfet L=0.55U W=10U AS=2.1P AD=2.1P PS=10.42U
+ PD=10.42U
* device instance $1602 r0 *1 145.225,440.17 pfet
M$1602 VDD_DRV x2_n5 OUT VDD_DRV pfet L=0.55U W=10U AS=2.1P AD=2.1P PS=10.42U
+ PD=10.42U
* device instance $1603 r0 *1 146.195,440.17 pfet
M$1603 OUT x2_n5 VDD_DRV VDD_DRV pfet L=0.55U W=10U AS=2.1P AD=2.1P PS=10.42U
+ PD=10.42U
* device instance $1604 r0 *1 147.165,440.17 pfet
M$1604 VDD_DRV x2_n5 OUT VDD_DRV pfet L=0.55U W=10U AS=2.1P AD=2.1P PS=10.42U
+ PD=10.42U
* device instance $1605 r0 *1 148.135,440.17 pfet
M$1605 OUT x2_n5 VDD_DRV VDD_DRV pfet L=0.55U W=10U AS=2.1P AD=2.1P PS=10.42U
+ PD=10.42U
* device instance $1606 r0 *1 149.105,440.17 pfet
M$1606 VDD_DRV x2_n5 OUT VDD_DRV pfet L=0.55U W=10U AS=2.1P AD=2.1P PS=10.42U
+ PD=10.42U
* device instance $1607 r0 *1 150.075,440.17 pfet
M$1607 OUT x2_n5 VDD_DRV VDD_DRV pfet L=0.55U W=10U AS=2.1P AD=2.1P PS=10.42U
+ PD=10.42U
* device instance $1608 r0 *1 151.045,440.17 pfet
M$1608 VDD_DRV x2_n5 OUT VDD_DRV pfet L=0.55U W=10U AS=2.1P AD=2.1P PS=10.42U
+ PD=10.42U
* device instance $1609 r0 *1 152.015,440.17 pfet
M$1609 OUT x2_n5 VDD_DRV VDD_DRV pfet L=0.55U W=10U AS=2.1P AD=2.1P PS=10.42U
+ PD=10.42U
* device instance $1610 r0 *1 152.985,440.17 pfet
M$1610 VDD_DRV x2_n5 OUT VDD_DRV pfet L=0.55U W=10U AS=2.1P AD=2.1P PS=10.42U
+ PD=10.42U
* device instance $1611 r0 *1 153.955,440.17 pfet
M$1611 OUT x2_n5 VDD_DRV VDD_DRV pfet L=0.55U W=10U AS=2.1P AD=2.1P PS=10.42U
+ PD=10.42U
* device instance $1612 r0 *1 154.925,440.17 pfet
M$1612 VDD_DRV x2_n5 OUT VDD_DRV pfet L=0.55U W=10U AS=2.1P AD=2.1P PS=10.42U
+ PD=10.42U
* device instance $1613 r0 *1 155.895,440.17 pfet
M$1613 OUT x2_n5 VDD_DRV VDD_DRV pfet L=0.55U W=10U AS=2.1P AD=2.1P PS=10.42U
+ PD=10.42U
* device instance $1614 r0 *1 156.865,440.17 pfet
M$1614 VDD_DRV x2_n5 OUT VDD_DRV pfet L=0.55U W=10U AS=2.1P AD=2.1P PS=10.42U
+ PD=10.42U
* device instance $1615 r0 *1 157.835,440.17 pfet
M$1615 OUT x2_n5 VDD_DRV VDD_DRV pfet L=0.55U W=10U AS=2.1P AD=2.1P PS=10.42U
+ PD=10.42U
* device instance $1616 r0 *1 158.805,440.17 pfet
M$1616 VDD_DRV x2_n5 OUT VDD_DRV pfet L=0.55U W=10U AS=2.1P AD=2.1P PS=10.42U
+ PD=10.42U
* device instance $1617 r0 *1 159.775,440.17 pfet
M$1617 OUT x2_n5 VDD_DRV VDD_DRV pfet L=0.55U W=10U AS=2.1P AD=2.1P PS=10.42U
+ PD=10.42U
* device instance $1618 r0 *1 160.745,440.17 pfet
M$1618 VDD_DRV x2_n5 OUT VDD_DRV pfet L=0.55U W=10U AS=2.1P AD=2.1P PS=10.42U
+ PD=10.42U
* device instance $1619 r0 *1 161.715,440.17 pfet
M$1619 OUT x2_n5 VDD_DRV VDD_DRV pfet L=0.55U W=10U AS=2.1P AD=2.1P PS=10.42U
+ PD=10.42U
* device instance $1620 r0 *1 162.685,440.17 pfet
M$1620 VDD_DRV x2_n5 OUT VDD_DRV pfet L=0.55U W=10U AS=2.1P AD=2.1P PS=10.42U
+ PD=10.42U
* device instance $1621 r0 *1 163.655,440.17 pfet
M$1621 OUT x2_n5 VDD_DRV VDD_DRV pfet L=0.55U W=10U AS=2.1P AD=2.1P PS=10.42U
+ PD=10.42U
* device instance $1622 r0 *1 164.625,440.17 pfet
M$1622 VDD_DRV x2_n5 OUT VDD_DRV pfet L=0.55U W=10U AS=2.1P AD=2.1P PS=10.42U
+ PD=10.42U
* device instance $1623 r0 *1 165.595,440.17 pfet
M$1623 OUT x2_n5 VDD_DRV VDD_DRV pfet L=0.55U W=10U AS=2.1P AD=2.1P PS=10.42U
+ PD=10.42U
* device instance $1624 r0 *1 166.565,440.17 pfet
M$1624 VDD_DRV x2_n5 OUT VDD_DRV pfet L=0.55U W=10U AS=2.1P AD=2.1P PS=10.42U
+ PD=10.42U
* device instance $1625 r0 *1 167.535,440.17 pfet
M$1625 OUT x2_n5 VDD_DRV VDD_DRV pfet L=0.55U W=10U AS=2.1P AD=2.1P PS=10.42U
+ PD=10.42U
* device instance $1626 r0 *1 168.505,440.17 pfet
M$1626 VDD_DRV x2_n5 OUT VDD_DRV pfet L=0.55U W=10U AS=2.1P AD=2.1P PS=10.42U
+ PD=10.42U
* device instance $1627 r0 *1 169.475,440.17 pfet
M$1627 OUT x2_n5 VDD_DRV VDD_DRV pfet L=0.55U W=10U AS=2.1P AD=2.1P PS=10.42U
+ PD=10.42U
* device instance $1628 r0 *1 170.445,440.17 pfet
M$1628 VDD_DRV x2_n5 OUT VDD_DRV pfet L=0.55U W=10U AS=2.1P AD=2.1P PS=10.42U
+ PD=10.42U
* device instance $1629 r0 *1 171.415,440.17 pfet
M$1629 OUT x2_n5 VDD_DRV VDD_DRV pfet L=0.55U W=10U AS=2.1P AD=2.1P PS=10.42U
+ PD=10.42U
* device instance $1630 r0 *1 172.385,440.17 pfet
M$1630 VDD_DRV x2_n5 OUT VDD_DRV pfet L=0.55U W=10U AS=2.1P AD=2.1P PS=10.42U
+ PD=10.42U
* device instance $1631 r0 *1 173.355,440.17 pfet
M$1631 OUT x2_n5 VDD_DRV VDD_DRV pfet L=0.55U W=10U AS=2.1P AD=2.1P PS=10.42U
+ PD=10.42U
* device instance $1632 r0 *1 174.325,440.17 pfet
M$1632 VDD_DRV x2_n5 OUT VDD_DRV pfet L=0.55U W=10U AS=2.1P AD=2.1P PS=10.42U
+ PD=10.42U
* device instance $1633 r0 *1 175.295,440.17 pfet
M$1633 OUT x2_n5 VDD_DRV VDD_DRV pfet L=0.55U W=10U AS=2.1P AD=2.1P PS=10.42U
+ PD=10.42U
* device instance $1634 r0 *1 176.265,440.17 pfet
M$1634 VDD_DRV x2_n5 OUT VDD_DRV pfet L=0.55U W=10U AS=2.1P AD=2.1P PS=10.42U
+ PD=10.42U
* device instance $1635 r0 *1 177.235,440.17 pfet
M$1635 OUT x2_n5 VDD_DRV VDD_DRV pfet L=0.55U W=10U AS=2.1P AD=2.1P PS=10.42U
+ PD=10.42U
* device instance $1636 r0 *1 178.205,440.17 pfet
M$1636 VDD_DRV x2_n5 OUT VDD_DRV pfet L=0.55U W=10U AS=2.1P AD=2.1P PS=10.42U
+ PD=10.42U
* device instance $1637 r0 *1 179.175,440.17 pfet
M$1637 OUT x2_n5 VDD_DRV VDD_DRV pfet L=0.55U W=10U AS=2.1P AD=2.1P PS=10.42U
+ PD=10.42U
* device instance $1638 r0 *1 180.145,440.17 pfet
M$1638 VDD_DRV x2_n5 OUT VDD_DRV pfet L=0.55U W=10U AS=2.1P AD=2.1P PS=10.42U
+ PD=10.42U
* device instance $1639 r0 *1 181.115,440.17 pfet
M$1639 OUT x2_n5 VDD_DRV VDD_DRV pfet L=0.55U W=10U AS=2.1P AD=2.1P PS=10.42U
+ PD=10.42U
* device instance $1640 r0 *1 121.945,440.17 pfet
M$1640 VDD_DRV x2_n5 OUT VDD_DRV pfet L=0.55U W=10U AS=2.1P AD=2.1P PS=10.42U
+ PD=10.42U
* device instance $1641 r0 *1 60.835,440.17 pfet
M$1641 OUT x2_n5 VDD_DRV VDD_DRV pfet L=0.55U W=10U AS=2.1P AD=2.1P PS=10.42U
+ PD=10.42U
* device instance $1642 r0 *1 61.805,440.17 pfet
M$1642 VDD_DRV x2_n5 OUT VDD_DRV pfet L=0.55U W=10U AS=2.1P AD=2.1P PS=10.42U
+ PD=10.42U
* device instance $1643 r0 *1 62.775,440.17 pfet
M$1643 OUT x2_n5 VDD_DRV VDD_DRV pfet L=0.55U W=10U AS=2.1P AD=2.1P PS=10.42U
+ PD=10.42U
* device instance $1644 r0 *1 63.745,440.17 pfet
M$1644 VDD_DRV x2_n5 OUT VDD_DRV pfet L=0.55U W=10U AS=2.1P AD=2.1P PS=10.42U
+ PD=10.42U
* device instance $1645 r0 *1 64.715,440.17 pfet
M$1645 OUT x2_n5 VDD_DRV VDD_DRV pfet L=0.55U W=10U AS=2.1P AD=2.1P PS=10.42U
+ PD=10.42U
* device instance $1646 r0 *1 65.685,440.17 pfet
M$1646 VDD_DRV x2_n5 OUT VDD_DRV pfet L=0.55U W=10U AS=2.1P AD=2.1P PS=10.42U
+ PD=10.42U
* device instance $1647 r0 *1 66.655,440.17 pfet
M$1647 OUT x2_n5 VDD_DRV VDD_DRV pfet L=0.55U W=10U AS=2.1P AD=2.1P PS=10.42U
+ PD=10.42U
* device instance $1648 r0 *1 67.625,440.17 pfet
M$1648 VDD_DRV x2_n5 OUT VDD_DRV pfet L=0.55U W=10U AS=2.1P AD=2.1P PS=10.42U
+ PD=10.42U
* device instance $1649 r0 *1 68.595,440.17 pfet
M$1649 OUT x2_n5 VDD_DRV VDD_DRV pfet L=0.55U W=10U AS=2.1P AD=2.1P PS=10.42U
+ PD=10.42U
* device instance $1650 r0 *1 69.565,440.17 pfet
M$1650 VDD_DRV x2_n5 OUT VDD_DRV pfet L=0.55U W=10U AS=2.1P AD=2.1P PS=10.42U
+ PD=10.42U
* device instance $1651 r0 *1 70.535,440.17 pfet
M$1651 OUT x2_n5 VDD_DRV VDD_DRV pfet L=0.55U W=10U AS=2.1P AD=2.1P PS=10.42U
+ PD=10.42U
* device instance $1652 r0 *1 71.505,440.17 pfet
M$1652 VDD_DRV x2_n5 OUT VDD_DRV pfet L=0.55U W=10U AS=2.1P AD=2.1P PS=10.42U
+ PD=10.42U
* device instance $1653 r0 *1 72.475,440.17 pfet
M$1653 OUT x2_n5 VDD_DRV VDD_DRV pfet L=0.55U W=10U AS=2.1P AD=2.1P PS=10.42U
+ PD=10.42U
* device instance $1654 r0 *1 73.445,440.17 pfet
M$1654 VDD_DRV x2_n5 OUT VDD_DRV pfet L=0.55U W=10U AS=2.1P AD=2.1P PS=10.42U
+ PD=10.42U
* device instance $1655 r0 *1 74.415,440.17 pfet
M$1655 OUT x2_n5 VDD_DRV VDD_DRV pfet L=0.55U W=10U AS=2.1P AD=2.1P PS=10.42U
+ PD=10.42U
* device instance $1656 r0 *1 75.385,440.17 pfet
M$1656 VDD_DRV x2_n5 OUT VDD_DRV pfet L=0.55U W=10U AS=2.1P AD=2.1P PS=10.42U
+ PD=10.42U
* device instance $1657 r0 *1 76.355,440.17 pfet
M$1657 OUT x2_n5 VDD_DRV VDD_DRV pfet L=0.55U W=10U AS=2.1P AD=2.1P PS=10.42U
+ PD=10.42U
* device instance $1658 r0 *1 77.325,440.17 pfet
M$1658 VDD_DRV x2_n5 OUT VDD_DRV pfet L=0.55U W=10U AS=2.1P AD=2.1P PS=10.42U
+ PD=10.42U
* device instance $1659 r0 *1 78.295,440.17 pfet
M$1659 OUT x2_n5 VDD_DRV VDD_DRV pfet L=0.55U W=10U AS=2.1P AD=2.1P PS=10.42U
+ PD=10.42U
* device instance $1660 r0 *1 79.265,440.17 pfet
M$1660 VDD_DRV x2_n5 OUT VDD_DRV pfet L=0.55U W=10U AS=2.1P AD=2.1P PS=10.42U
+ PD=10.42U
* device instance $1661 r0 *1 80.235,440.17 pfet
M$1661 OUT x2_n5 VDD_DRV VDD_DRV pfet L=0.55U W=10U AS=2.1P AD=2.1P PS=10.42U
+ PD=10.42U
* device instance $1662 r0 *1 81.205,440.17 pfet
M$1662 VDD_DRV x2_n5 OUT VDD_DRV pfet L=0.55U W=10U AS=2.1P AD=2.1P PS=10.42U
+ PD=10.42U
* device instance $1663 r0 *1 82.175,440.17 pfet
M$1663 OUT x2_n5 VDD_DRV VDD_DRV pfet L=0.55U W=10U AS=2.1P AD=2.1P PS=10.42U
+ PD=10.42U
* device instance $1664 r0 *1 83.145,440.17 pfet
M$1664 VDD_DRV x2_n5 OUT VDD_DRV pfet L=0.55U W=10U AS=2.1P AD=2.1P PS=10.42U
+ PD=10.42U
* device instance $1665 r0 *1 84.115,440.17 pfet
M$1665 OUT x2_n5 VDD_DRV VDD_DRV pfet L=0.55U W=10U AS=2.1P AD=2.1P PS=10.42U
+ PD=10.42U
* device instance $1666 r0 *1 85.085,440.17 pfet
M$1666 VDD_DRV x2_n5 OUT VDD_DRV pfet L=0.55U W=10U AS=2.1P AD=2.1P PS=10.42U
+ PD=10.42U
* device instance $1667 r0 *1 86.055,440.17 pfet
M$1667 OUT x2_n5 VDD_DRV VDD_DRV pfet L=0.55U W=10U AS=2.1P AD=2.1P PS=10.42U
+ PD=10.42U
* device instance $1668 r0 *1 87.025,440.17 pfet
M$1668 VDD_DRV x2_n5 OUT VDD_DRV pfet L=0.55U W=10U AS=2.1P AD=2.1P PS=10.42U
+ PD=10.42U
* device instance $1669 r0 *1 87.995,440.17 pfet
M$1669 OUT x2_n5 VDD_DRV VDD_DRV pfet L=0.55U W=10U AS=2.1P AD=2.1P PS=10.42U
+ PD=10.42U
* device instance $1670 r0 *1 88.965,440.17 pfet
M$1670 VDD_DRV x2_n5 OUT VDD_DRV pfet L=0.55U W=10U AS=2.1P AD=2.1P PS=10.42U
+ PD=10.42U
* device instance $1671 r0 *1 89.935,440.17 pfet
M$1671 OUT x2_n5 VDD_DRV VDD_DRV pfet L=0.55U W=10U AS=2.1P AD=2.1P PS=10.42U
+ PD=10.42U
* device instance $1672 r0 *1 90.905,440.17 pfet
M$1672 VDD_DRV x2_n5 OUT VDD_DRV pfet L=0.55U W=10U AS=2.1P AD=2.1P PS=10.42U
+ PD=10.42U
* device instance $1673 r0 *1 91.875,440.17 pfet
M$1673 OUT x2_n5 VDD_DRV VDD_DRV pfet L=0.55U W=10U AS=2.1P AD=2.1P PS=10.42U
+ PD=10.42U
* device instance $1674 r0 *1 92.845,440.17 pfet
M$1674 VDD_DRV x2_n5 OUT VDD_DRV pfet L=0.55U W=10U AS=2.1P AD=2.1P PS=10.42U
+ PD=10.42U
* device instance $1675 r0 *1 93.815,440.17 pfet
M$1675 OUT x2_n5 VDD_DRV VDD_DRV pfet L=0.55U W=10U AS=2.1P AD=2.1P PS=10.42U
+ PD=10.42U
* device instance $1676 r0 *1 94.785,440.17 pfet
M$1676 VDD_DRV x2_n5 OUT VDD_DRV pfet L=0.55U W=10U AS=2.1P AD=2.1P PS=10.42U
+ PD=10.42U
* device instance $1677 r0 *1 95.755,440.17 pfet
M$1677 OUT x2_n5 VDD_DRV VDD_DRV pfet L=0.55U W=10U AS=2.1P AD=2.1P PS=10.42U
+ PD=10.42U
* device instance $1678 r0 *1 96.725,440.17 pfet
M$1678 VDD_DRV x2_n5 OUT VDD_DRV pfet L=0.55U W=10U AS=2.1P AD=2.1P PS=10.42U
+ PD=10.42U
* device instance $1679 r0 *1 97.695,440.17 pfet
M$1679 OUT x2_n5 VDD_DRV VDD_DRV pfet L=0.55U W=10U AS=2.1P AD=2.1P PS=10.42U
+ PD=10.42U
* device instance $1680 r0 *1 98.665,440.17 pfet
M$1680 VDD_DRV x2_n5 OUT VDD_DRV pfet L=0.55U W=10U AS=2.1P AD=2.1P PS=10.42U
+ PD=10.42U
* device instance $1681 r0 *1 99.635,440.17 pfet
M$1681 OUT x2_n5 VDD_DRV VDD_DRV pfet L=0.55U W=10U AS=2.1P AD=2.1P PS=10.42U
+ PD=10.42U
* device instance $1682 r0 *1 100.605,440.17 pfet
M$1682 VDD_DRV x2_n5 OUT VDD_DRV pfet L=0.55U W=10U AS=2.1P AD=2.1P PS=10.42U
+ PD=10.42U
* device instance $1683 r0 *1 101.575,440.17 pfet
M$1683 OUT x2_n5 VDD_DRV VDD_DRV pfet L=0.55U W=10U AS=2.1P AD=2.1P PS=10.42U
+ PD=10.42U
* device instance $1684 r0 *1 102.545,440.17 pfet
M$1684 VDD_DRV x2_n5 OUT VDD_DRV pfet L=0.55U W=10U AS=2.1P AD=2.1P PS=10.42U
+ PD=10.42U
* device instance $1685 r0 *1 103.515,440.17 pfet
M$1685 OUT x2_n5 VDD_DRV VDD_DRV pfet L=0.55U W=10U AS=2.1P AD=2.1P PS=10.42U
+ PD=10.42U
* device instance $1686 r0 *1 104.485,440.17 pfet
M$1686 VDD_DRV x2_n5 OUT VDD_DRV pfet L=0.55U W=10U AS=2.1P AD=2.1P PS=10.42U
+ PD=10.42U
* device instance $1687 r0 *1 105.455,440.17 pfet
M$1687 OUT x2_n5 VDD_DRV VDD_DRV pfet L=0.55U W=10U AS=2.1P AD=2.1P PS=10.42U
+ PD=10.42U
* device instance $1688 r0 *1 106.425,440.17 pfet
M$1688 VDD_DRV x2_n5 OUT VDD_DRV pfet L=0.55U W=10U AS=2.1P AD=2.1P PS=10.42U
+ PD=10.42U
* device instance $1689 r0 *1 107.395,440.17 pfet
M$1689 OUT x2_n5 VDD_DRV VDD_DRV pfet L=0.55U W=10U AS=2.1P AD=2.1P PS=10.42U
+ PD=10.42U
* device instance $1690 r0 *1 108.365,440.17 pfet
M$1690 VDD_DRV x2_n5 OUT VDD_DRV pfet L=0.55U W=10U AS=2.1P AD=2.1P PS=10.42U
+ PD=10.42U
* device instance $1691 r0 *1 109.335,440.17 pfet
M$1691 OUT x2_n5 VDD_DRV VDD_DRV pfet L=0.55U W=10U AS=2.1P AD=2.1P PS=10.42U
+ PD=10.42U
* device instance $1692 r0 *1 110.305,440.17 pfet
M$1692 VDD_DRV x2_n5 OUT VDD_DRV pfet L=0.55U W=10U AS=2.1P AD=2.1P PS=10.42U
+ PD=10.42U
* device instance $1693 r0 *1 111.275,440.17 pfet
M$1693 OUT x2_n5 VDD_DRV VDD_DRV pfet L=0.55U W=10U AS=2.1P AD=2.1P PS=10.42U
+ PD=10.42U
* device instance $1694 r0 *1 112.245,440.17 pfet
M$1694 VDD_DRV x2_n5 OUT VDD_DRV pfet L=0.55U W=10U AS=2.1P AD=2.1P PS=10.42U
+ PD=10.42U
* device instance $1695 r0 *1 113.215,440.17 pfet
M$1695 OUT x2_n5 VDD_DRV VDD_DRV pfet L=0.55U W=10U AS=2.1P AD=2.1P PS=10.42U
+ PD=10.42U
* device instance $1696 r0 *1 114.185,440.17 pfet
M$1696 VDD_DRV x2_n5 OUT VDD_DRV pfet L=0.55U W=10U AS=2.1P AD=2.1P PS=10.42U
+ PD=10.42U
* device instance $1697 r0 *1 115.155,440.17 pfet
M$1697 OUT x2_n5 VDD_DRV VDD_DRV pfet L=0.55U W=10U AS=2.1P AD=2.1P PS=10.42U
+ PD=10.42U
* device instance $1698 r0 *1 116.125,440.17 pfet
M$1698 VDD_DRV x2_n5 OUT VDD_DRV pfet L=0.55U W=10U AS=2.1P AD=2.1P PS=10.42U
+ PD=10.42U
* device instance $1699 r0 *1 117.095,440.17 pfet
M$1699 OUT x2_n5 VDD_DRV VDD_DRV pfet L=0.55U W=10U AS=2.1P AD=2.1P PS=10.42U
+ PD=10.42U
* device instance $1700 r0 *1 118.065,440.17 pfet
M$1700 VDD_DRV x2_n5 OUT VDD_DRV pfet L=0.55U W=10U AS=2.1P AD=2.1P PS=10.42U
+ PD=10.42U
* device instance $1701 r0 *1 119.035,440.17 pfet
M$1701 OUT x2_n5 VDD_DRV VDD_DRV pfet L=0.55U W=10U AS=2.1P AD=2.1P PS=10.42U
+ PD=10.42U
* device instance $1702 r0 *1 120.005,440.17 pfet
M$1702 VDD_DRV x2_n5 OUT VDD_DRV pfet L=0.55U W=10U AS=2.1P AD=2.1P PS=10.42U
+ PD=10.42U
* device instance $1703 r0 *1 120.975,440.17 pfet
M$1703 OUT x2_n5 VDD_DRV VDD_DRV pfet L=0.55U W=10U AS=2.1P AD=2.1P PS=10.42U
+ PD=10.42U
* device instance $1704 r0 *1 1.665,440.17 pfet
M$1704 VDD_DRV x2_n5 OUT VDD_DRV pfet L=0.55U W=10U AS=2.1P AD=2.1P PS=10.42U
+ PD=10.42U
* device instance $1705 r0 *1 2.635,440.17 pfet
M$1705 OUT x2_n5 VDD_DRV VDD_DRV pfet L=0.55U W=10U AS=2.1P AD=2.1P PS=10.42U
+ PD=10.42U
* device instance $1706 r0 *1 3.605,440.17 pfet
M$1706 VDD_DRV x2_n5 OUT VDD_DRV pfet L=0.55U W=10U AS=2.1P AD=2.1P PS=10.42U
+ PD=10.42U
* device instance $1707 r0 *1 4.575,440.17 pfet
M$1707 OUT x2_n5 VDD_DRV VDD_DRV pfet L=0.55U W=10U AS=2.1P AD=2.1P PS=10.42U
+ PD=10.42U
* device instance $1708 r0 *1 5.545,440.17 pfet
M$1708 VDD_DRV x2_n5 OUT VDD_DRV pfet L=0.55U W=10U AS=2.1P AD=2.1P PS=10.42U
+ PD=10.42U
* device instance $1709 r0 *1 6.515,440.17 pfet
M$1709 OUT x2_n5 VDD_DRV VDD_DRV pfet L=0.55U W=10U AS=2.1P AD=2.1P PS=10.42U
+ PD=10.42U
* device instance $1710 r0 *1 7.485,440.17 pfet
M$1710 VDD_DRV x2_n5 OUT VDD_DRV pfet L=0.55U W=10U AS=2.1P AD=2.1P PS=10.42U
+ PD=10.42U
* device instance $1711 r0 *1 8.455,440.17 pfet
M$1711 OUT x2_n5 VDD_DRV VDD_DRV pfet L=0.55U W=10U AS=2.1P AD=2.1P PS=10.42U
+ PD=10.42U
* device instance $1712 r0 *1 9.425,440.17 pfet
M$1712 VDD_DRV x2_n5 OUT VDD_DRV pfet L=0.55U W=10U AS=2.1P AD=2.1P PS=10.42U
+ PD=10.42U
* device instance $1713 r0 *1 10.395,440.17 pfet
M$1713 OUT x2_n5 VDD_DRV VDD_DRV pfet L=0.55U W=10U AS=2.1P AD=2.1P PS=10.42U
+ PD=10.42U
* device instance $1714 r0 *1 11.365,440.17 pfet
M$1714 VDD_DRV x2_n5 OUT VDD_DRV pfet L=0.55U W=10U AS=2.1P AD=2.1P PS=10.42U
+ PD=10.42U
* device instance $1715 r0 *1 12.335,440.17 pfet
M$1715 OUT x2_n5 VDD_DRV VDD_DRV pfet L=0.55U W=10U AS=2.1P AD=2.1P PS=10.42U
+ PD=10.42U
* device instance $1716 r0 *1 13.305,440.17 pfet
M$1716 VDD_DRV x2_n5 OUT VDD_DRV pfet L=0.55U W=10U AS=2.1P AD=2.1P PS=10.42U
+ PD=10.42U
* device instance $1717 r0 *1 14.275,440.17 pfet
M$1717 OUT x2_n5 VDD_DRV VDD_DRV pfet L=0.55U W=10U AS=2.1P AD=2.1P PS=10.42U
+ PD=10.42U
* device instance $1718 r0 *1 15.245,440.17 pfet
M$1718 VDD_DRV x2_n5 OUT VDD_DRV pfet L=0.55U W=10U AS=2.1P AD=2.1P PS=10.42U
+ PD=10.42U
* device instance $1719 r0 *1 16.215,440.17 pfet
M$1719 OUT x2_n5 VDD_DRV VDD_DRV pfet L=0.55U W=10U AS=2.1P AD=2.1P PS=10.42U
+ PD=10.42U
* device instance $1720 r0 *1 17.185,440.17 pfet
M$1720 VDD_DRV x2_n5 OUT VDD_DRV pfet L=0.55U W=10U AS=2.1P AD=2.1P PS=10.42U
+ PD=10.42U
* device instance $1721 r0 *1 18.155,440.17 pfet
M$1721 OUT x2_n5 VDD_DRV VDD_DRV pfet L=0.55U W=10U AS=2.1P AD=2.1P PS=10.42U
+ PD=10.42U
* device instance $1722 r0 *1 19.125,440.17 pfet
M$1722 VDD_DRV x2_n5 OUT VDD_DRV pfet L=0.55U W=10U AS=2.1P AD=2.1P PS=10.42U
+ PD=10.42U
* device instance $1723 r0 *1 20.095,440.17 pfet
M$1723 OUT x2_n5 VDD_DRV VDD_DRV pfet L=0.55U W=10U AS=2.1P AD=2.1P PS=10.42U
+ PD=10.42U
* device instance $1724 r0 *1 21.065,440.17 pfet
M$1724 VDD_DRV x2_n5 OUT VDD_DRV pfet L=0.55U W=10U AS=2.1P AD=2.1P PS=10.42U
+ PD=10.42U
* device instance $1725 r0 *1 22.035,440.17 pfet
M$1725 OUT x2_n5 VDD_DRV VDD_DRV pfet L=0.55U W=10U AS=2.1P AD=2.1P PS=10.42U
+ PD=10.42U
* device instance $1726 r0 *1 23.005,440.17 pfet
M$1726 VDD_DRV x2_n5 OUT VDD_DRV pfet L=0.55U W=10U AS=2.1P AD=2.1P PS=10.42U
+ PD=10.42U
* device instance $1727 r0 *1 23.975,440.17 pfet
M$1727 OUT x2_n5 VDD_DRV VDD_DRV pfet L=0.55U W=10U AS=2.1P AD=2.1P PS=10.42U
+ PD=10.42U
* device instance $1728 r0 *1 24.945,440.17 pfet
M$1728 VDD_DRV x2_n5 OUT VDD_DRV pfet L=0.55U W=10U AS=2.1P AD=2.1P PS=10.42U
+ PD=10.42U
* device instance $1729 r0 *1 25.915,440.17 pfet
M$1729 OUT x2_n5 VDD_DRV VDD_DRV pfet L=0.55U W=10U AS=2.1P AD=2.1P PS=10.42U
+ PD=10.42U
* device instance $1730 r0 *1 26.885,440.17 pfet
M$1730 VDD_DRV x2_n5 OUT VDD_DRV pfet L=0.55U W=10U AS=2.1P AD=2.1P PS=10.42U
+ PD=10.42U
* device instance $1731 r0 *1 27.855,440.17 pfet
M$1731 OUT x2_n5 VDD_DRV VDD_DRV pfet L=0.55U W=10U AS=2.1P AD=2.1P PS=10.42U
+ PD=10.42U
* device instance $1732 r0 *1 28.825,440.17 pfet
M$1732 VDD_DRV x2_n5 OUT VDD_DRV pfet L=0.55U W=10U AS=2.1P AD=2.1P PS=10.42U
+ PD=10.42U
* device instance $1733 r0 *1 29.795,440.17 pfet
M$1733 OUT x2_n5 VDD_DRV VDD_DRV pfet L=0.55U W=10U AS=2.1P AD=2.1P PS=10.42U
+ PD=10.42U
* device instance $1734 r0 *1 30.765,440.17 pfet
M$1734 VDD_DRV x2_n5 OUT VDD_DRV pfet L=0.55U W=10U AS=2.1P AD=2.1P PS=10.42U
+ PD=10.42U
* device instance $1735 r0 *1 31.735,440.17 pfet
M$1735 OUT x2_n5 VDD_DRV VDD_DRV pfet L=0.55U W=10U AS=2.1P AD=2.1P PS=10.42U
+ PD=10.42U
* device instance $1736 r0 *1 32.705,440.17 pfet
M$1736 VDD_DRV x2_n5 OUT VDD_DRV pfet L=0.55U W=10U AS=2.1P AD=2.1P PS=10.42U
+ PD=10.42U
* device instance $1737 r0 *1 33.675,440.17 pfet
M$1737 OUT x2_n5 VDD_DRV VDD_DRV pfet L=0.55U W=10U AS=2.1P AD=2.1P PS=10.42U
+ PD=10.42U
* device instance $1738 r0 *1 34.645,440.17 pfet
M$1738 VDD_DRV x2_n5 OUT VDD_DRV pfet L=0.55U W=10U AS=2.1P AD=2.1P PS=10.42U
+ PD=10.42U
* device instance $1739 r0 *1 35.615,440.17 pfet
M$1739 OUT x2_n5 VDD_DRV VDD_DRV pfet L=0.55U W=10U AS=2.1P AD=2.1P PS=10.42U
+ PD=10.42U
* device instance $1740 r0 *1 36.585,440.17 pfet
M$1740 VDD_DRV x2_n5 OUT VDD_DRV pfet L=0.55U W=10U AS=2.1P AD=2.1P PS=10.42U
+ PD=10.42U
* device instance $1741 r0 *1 37.555,440.17 pfet
M$1741 OUT x2_n5 VDD_DRV VDD_DRV pfet L=0.55U W=10U AS=2.1P AD=2.1P PS=10.42U
+ PD=10.42U
* device instance $1742 r0 *1 38.525,440.17 pfet
M$1742 VDD_DRV x2_n5 OUT VDD_DRV pfet L=0.55U W=10U AS=2.1P AD=2.1P PS=10.42U
+ PD=10.42U
* device instance $1743 r0 *1 39.495,440.17 pfet
M$1743 OUT x2_n5 VDD_DRV VDD_DRV pfet L=0.55U W=10U AS=2.1P AD=2.1P PS=10.42U
+ PD=10.42U
* device instance $1744 r0 *1 40.465,440.17 pfet
M$1744 VDD_DRV x2_n5 OUT VDD_DRV pfet L=0.55U W=10U AS=2.1P AD=2.1P PS=10.42U
+ PD=10.42U
* device instance $1745 r0 *1 41.435,440.17 pfet
M$1745 OUT x2_n5 VDD_DRV VDD_DRV pfet L=0.55U W=10U AS=2.1P AD=2.1P PS=10.42U
+ PD=10.42U
* device instance $1746 r0 *1 42.405,440.17 pfet
M$1746 VDD_DRV x2_n5 OUT VDD_DRV pfet L=0.55U W=10U AS=2.1P AD=2.1P PS=10.42U
+ PD=10.42U
* device instance $1747 r0 *1 43.375,440.17 pfet
M$1747 OUT x2_n5 VDD_DRV VDD_DRV pfet L=0.55U W=10U AS=2.1P AD=2.1P PS=10.42U
+ PD=10.42U
* device instance $1748 r0 *1 44.345,440.17 pfet
M$1748 VDD_DRV x2_n5 OUT VDD_DRV pfet L=0.55U W=10U AS=2.1P AD=2.1P PS=10.42U
+ PD=10.42U
* device instance $1749 r0 *1 45.315,440.17 pfet
M$1749 OUT x2_n5 VDD_DRV VDD_DRV pfet L=0.55U W=10U AS=2.1P AD=2.1P PS=10.42U
+ PD=10.42U
* device instance $1750 r0 *1 46.285,440.17 pfet
M$1750 VDD_DRV x2_n5 OUT VDD_DRV pfet L=0.55U W=10U AS=2.1P AD=2.1P PS=10.42U
+ PD=10.42U
* device instance $1751 r0 *1 47.255,440.17 pfet
M$1751 OUT x2_n5 VDD_DRV VDD_DRV pfet L=0.55U W=10U AS=2.1P AD=2.1P PS=10.42U
+ PD=10.42U
* device instance $1752 r0 *1 48.225,440.17 pfet
M$1752 VDD_DRV x2_n5 OUT VDD_DRV pfet L=0.55U W=10U AS=2.1P AD=2.1P PS=10.42U
+ PD=10.42U
* device instance $1753 r0 *1 49.195,440.17 pfet
M$1753 OUT x2_n5 VDD_DRV VDD_DRV pfet L=0.55U W=10U AS=2.1P AD=2.1P PS=10.42U
+ PD=10.42U
* device instance $1754 r0 *1 50.165,440.17 pfet
M$1754 VDD_DRV x2_n5 OUT VDD_DRV pfet L=0.55U W=10U AS=2.1P AD=2.1P PS=10.42U
+ PD=10.42U
* device instance $1755 r0 *1 51.135,440.17 pfet
M$1755 OUT x2_n5 VDD_DRV VDD_DRV pfet L=0.55U W=10U AS=2.1P AD=2.1P PS=10.42U
+ PD=10.42U
* device instance $1756 r0 *1 52.105,440.17 pfet
M$1756 VDD_DRV x2_n5 OUT VDD_DRV pfet L=0.55U W=10U AS=2.1P AD=2.1P PS=10.42U
+ PD=10.42U
* device instance $1757 r0 *1 53.075,440.17 pfet
M$1757 OUT x2_n5 VDD_DRV VDD_DRV pfet L=0.55U W=10U AS=2.1P AD=2.1P PS=10.42U
+ PD=10.42U
* device instance $1758 r0 *1 54.045,440.17 pfet
M$1758 VDD_DRV x2_n5 OUT VDD_DRV pfet L=0.55U W=10U AS=2.1P AD=2.1P PS=10.42U
+ PD=10.42U
* device instance $1759 r0 *1 55.015,440.17 pfet
M$1759 OUT x2_n5 VDD_DRV VDD_DRV pfet L=0.55U W=10U AS=2.1P AD=2.1P PS=10.42U
+ PD=10.42U
* device instance $1760 r0 *1 55.985,440.17 pfet
M$1760 VDD_DRV x2_n5 OUT VDD_DRV pfet L=0.55U W=10U AS=2.1P AD=2.1P PS=10.42U
+ PD=10.42U
* device instance $1761 r0 *1 56.955,440.17 pfet
M$1761 OUT x2_n5 VDD_DRV VDD_DRV pfet L=0.55U W=10U AS=2.1P AD=2.1P PS=10.42U
+ PD=10.42U
* device instance $1762 r0 *1 57.925,440.17 pfet
M$1762 VDD_DRV x2_n5 OUT VDD_DRV pfet L=0.55U W=10U AS=2.1P AD=2.1P PS=10.42U
+ PD=10.42U
* device instance $1763 r0 *1 58.895,440.17 pfet
M$1763 OUT x2_n5 VDD_DRV VDD_DRV pfet L=0.55U W=10U AS=2.1P AD=2.1P PS=10.42U
+ PD=10.42U
* device instance $1764 r0 *1 59.865,440.17 pfet
M$1764 VDD_DRV x2_n5 OUT VDD_DRV pfet L=0.55U W=10U AS=2.1P AD=2.1P PS=10.42U
+ PD=10.42U
* device instance $1765 r0 *1 0.695,440.17 pfet
M$1765 OUT x2_n5 VDD_DRV VDD_DRV pfet L=0.55U W=10U AS=4.2P AD=2.1P PS=20.84U
+ PD=10.42U
* device instance $1766 r0 *1 0.695,614.03 pfet
M$1766 x3_uvlo_ok x3_lockout VDD_DRV VDD_DRV pfet L=0.55U W=20U AS=8.4P AD=8.4P
+ PS=40.84U PD=40.84U
* device instance $1767 r0 *1 0.695,549.55 pfet
M$1767 x3_ncompp x3_ncompp VDD_DRV VDD_DRV pfet L=0.55U W=15U AS=6.3P AD=6.3P
+ PS=30.84U PD=30.84U
* device instance $1768 r0 *1 0.695,568.87 pfet
M$1768 x3_ncompn x3_ncompp VDD_DRV VDD_DRV pfet L=0.55U W=15U AS=6.3P AD=6.3P
+ PS=30.84U PD=30.84U
* device instance $1769 r0 *1 0.695,585.69 pfet
M$1769 x3_lockout x3_ncompn VDD_DRV VDD_DRV pfet L=0.55U W=10U AS=4.2P AD=4.2P
+ PS=20.84U PD=20.84U
* device instance $1770 r0 *1 3.1,709.68 cap_mim_2f0_m4m5_noshield
C$1770 x1_ncb \$293 5.4516e-14 cap_mim_2f0_m4m5_noshield
* device instance $1771 r0 *1 10.5,709.68 cap_mim_2f0_m4m5_noshield
C$1771 \$294 \$293 5.4516e-14 cap_mim_2f0_m4m5_noshield
* device instance $1772 r0 *1 17.9,709.68 cap_mim_2f0_m4m5_noshield
C$1772 \$294 \$295 5.4516e-14 cap_mim_2f0_m4m5_noshield
* device instance $1773 r0 *1 25.3,709.68 cap_mim_2f0_m4m5_noshield
C$1773 IN_DRV \$295 5.4516e-14 cap_mim_2f0_m4m5_noshield
* device instance $1774 r0 *1 989.24,-0.19 ppolyf_u
R$1774 VDD_DRV \$22 GND_LOGIC 66666.6666667 ppolyf_u
* device instance $1775 r0 *1 1070.58,-0.19 ppolyf_u
R$1775 \$22 \$23 GND_LOGIC 66666.6666667 ppolyf_u
* device instance $1776 r0 *1 1151.92,-0.19 ppolyf_u
R$1776 \$23 \$26 GND_LOGIC 66666.6666667 ppolyf_u
* device instance $1777 r0 *1 1233.26,-0.19 ppolyf_u
R$1777 \$26 \$27 GND_LOGIC 66666.6666667 ppolyf_u
* device instance $1778 r0 *1 1314.6,-0.19 ppolyf_u
R$1778 \$27 \$30 GND_LOGIC 66666.6666667 ppolyf_u
* device instance $1779 r0 *1 1395.94,-0.19 ppolyf_u
R$1779 \$30 \$31 GND_LOGIC 66666.6666667 ppolyf_u
* device instance $1780 r0 *1 989.24,0.63 ppolyf_u
R$1780 x3_nref \$21 GND_LOGIC 66666.6666667 ppolyf_u
* device instance $1781 r0 *1 1070.58,0.63 ppolyf_u
R$1781 \$21 \$24 GND_LOGIC 66666.6666667 ppolyf_u
* device instance $1782 r0 *1 1151.92,0.63 ppolyf_u
R$1782 \$24 \$25 GND_LOGIC 66666.6666667 ppolyf_u
* device instance $1783 r0 *1 1233.26,0.63 ppolyf_u
R$1783 \$25 \$28 GND_LOGIC 66666.6666667 ppolyf_u
* device instance $1784 r0 *1 1314.6,0.63 ppolyf_u
R$1784 \$28 \$29 GND_LOGIC 66666.6666667 ppolyf_u
* device instance $1785 r0 *1 1395.94,0.63 ppolyf_u
R$1785 \$29 \$31 GND_LOGIC 66666.6666667 ppolyf_u
* device instance $1786 r0 *1 982.24,7.05 ppolyf_u
R$1786 VDD_DRV \$32 GND_LOGIC 55000 ppolyf_u
* device instance $1787 r0 *1 1049.58,7.05 ppolyf_u
R$1787 \$32 \$33 GND_LOGIC 55000 ppolyf_u
* device instance $1788 r0 *1 1116.92,7.05 ppolyf_u
R$1788 \$33 \$34 GND_LOGIC 55000 ppolyf_u
* device instance $1789 r0 *1 1184.26,7.05 ppolyf_u
R$1789 \$34 \$35 GND_LOGIC 55000 ppolyf_u
* device instance $1790 r0 *1 1251.6,7.05 ppolyf_u
R$1790 \$35 \$36 GND_LOGIC 55000 ppolyf_u
* device instance $1791 r0 *1 1318.94,7.05 ppolyf_u
R$1791 \$36 \$37 GND_LOGIC 55000 ppolyf_u
* device instance $1792 r0 *1 1386.28,7.05 ppolyf_u
R$1792 \$37 \$38 GND_LOGIC 55000 ppolyf_u
* device instance $1793 r0 *1 1453.62,7.05 ppolyf_u
R$1793 \$38 \$39 GND_LOGIC 55000 ppolyf_u
* device instance $1794 r0 *1 982.24,7.87 ppolyf_u
R$1794 x3_ndiv \$40 GND_LOGIC 55000 ppolyf_u
* device instance $1795 r0 *1 1049.58,7.87 ppolyf_u
R$1795 \$40 \$42 GND_LOGIC 55000 ppolyf_u
* device instance $1796 r0 *1 1116.92,7.87 ppolyf_u
R$1796 \$42 \$44 GND_LOGIC 55000 ppolyf_u
* device instance $1797 r0 *1 1184.26,7.87 ppolyf_u
R$1797 \$44 \$45 GND_LOGIC 55000 ppolyf_u
* device instance $1798 r0 *1 1251.6,7.87 ppolyf_u
R$1798 \$45 \$46 GND_LOGIC 55000 ppolyf_u
* device instance $1799 r0 *1 1318.94,7.87 ppolyf_u
R$1799 \$46 \$47 GND_LOGIC 55000 ppolyf_u
* device instance $1800 r0 *1 1386.28,7.87 ppolyf_u
R$1800 \$47 \$48 GND_LOGIC 55000 ppolyf_u
* device instance $1801 r0 *1 1453.62,7.87 ppolyf_u
R$1801 \$48 \$39 GND_LOGIC 55000 ppolyf_u
* device instance $1802 r0 *1 989.24,20.71 ppolyf_u
R$1802 x3_uvlo_ok \$49 GND_LOGIC 66666.6666667 ppolyf_u
* device instance $1803 r0 *1 989.24,14.29 ppolyf_u
R$1803 x3_ndiv \$41 GND_LOGIC 66666.6666667 ppolyf_u
* device instance $1804 r0 *1 1070.58,20.71 ppolyf_u
R$1804 \$49 \$50 GND_LOGIC 66666.6666667 ppolyf_u
* device instance $1805 r0 *1 1070.58,14.29 ppolyf_u
R$1805 \$41 \$43 GND_LOGIC 66666.6666667 ppolyf_u
* device instance $1806 r0 *1 1151.92,20.71 ppolyf_u
R$1806 \$50 \$51 GND_LOGIC 66666.6666667 ppolyf_u
* device instance $1807 r0 *1 1151.92,14.29 ppolyf_u
R$1807 \$43 GND_DRV GND_LOGIC 66666.6666667 ppolyf_u
* device instance $1808 r0 *1 1233.26,20.71 ppolyf_u
R$1808 \$51 \$52 GND_LOGIC 66666.6666667 ppolyf_u
* device instance $1809 r0 *1 1314.6,20.71 ppolyf_u
R$1809 \$52 \$53 GND_LOGIC 66666.6666667 ppolyf_u
* device instance $1810 r0 *1 1395.94,20.71 ppolyf_u
R$1810 \$53 \$54 GND_LOGIC 66666.6666667 ppolyf_u
* device instance $1811 r0 *1 1477.28,20.71 ppolyf_u
R$1811 \$54 \$55 GND_LOGIC 66666.6666667 ppolyf_u
* device instance $1812 r0 *1 1558.62,20.71 ppolyf_u
R$1812 \$55 \$56 GND_LOGIC 66666.6666667 ppolyf_u
* device instance $1813 r0 *1 989.24,21.53 ppolyf_u
R$1813 \$57 \$59 GND_LOGIC 66666.6666667 ppolyf_u
* device instance $1814 r0 *1 1070.58,21.53 ppolyf_u
R$1814 \$59 \$60 GND_LOGIC 66666.6666667 ppolyf_u
* device instance $1815 r0 *1 1151.92,21.53 ppolyf_u
R$1815 \$60 \$63 GND_LOGIC 66666.6666667 ppolyf_u
* device instance $1816 r0 *1 1233.26,21.53 ppolyf_u
R$1816 \$63 \$65 GND_LOGIC 66666.6666667 ppolyf_u
* device instance $1817 r0 *1 1314.6,21.53 ppolyf_u
R$1817 \$65 \$66 GND_LOGIC 66666.6666667 ppolyf_u
* device instance $1818 r0 *1 1395.94,21.53 ppolyf_u
R$1818 \$66 \$69 GND_LOGIC 66666.6666667 ppolyf_u
* device instance $1819 r0 *1 1477.28,21.53 ppolyf_u
R$1819 \$69 \$71 GND_LOGIC 66666.6666667 ppolyf_u
* device instance $1820 r0 *1 1558.62,21.53 ppolyf_u
R$1820 \$71 \$56 GND_LOGIC 66666.6666667 ppolyf_u
* device instance $1821 r0 *1 989.24,22.35 ppolyf_u
R$1821 \$57 \$58 GND_LOGIC 66666.6666667 ppolyf_u
* device instance $1822 r0 *1 1070.58,22.35 ppolyf_u
R$1822 \$58 \$61 GND_LOGIC 66666.6666667 ppolyf_u
* device instance $1823 r0 *1 1151.92,22.35 ppolyf_u
R$1823 \$61 \$62 GND_LOGIC 66666.6666667 ppolyf_u
* device instance $1824 r0 *1 1233.26,22.35 ppolyf_u
R$1824 \$62 \$64 GND_LOGIC 66666.6666667 ppolyf_u
* device instance $1825 r0 *1 1314.6,22.35 ppolyf_u
R$1825 \$64 \$67 GND_LOGIC 66666.6666667 ppolyf_u
* device instance $1826 r0 *1 1395.94,22.35 ppolyf_u
R$1826 \$67 \$68 GND_LOGIC 66666.6666667 ppolyf_u
* device instance $1827 r0 *1 1477.28,22.35 ppolyf_u
R$1827 \$68 \$70 GND_LOGIC 66666.6666667 ppolyf_u
* device instance $1828 r0 *1 1558.62,22.35 ppolyf_u
R$1828 \$70 \$72 GND_LOGIC 66666.6666667 ppolyf_u
* device instance $1829 r0 *1 989.24,23.17 ppolyf_u
R$1829 \$73 \$74 GND_LOGIC 66666.6666667 ppolyf_u
* device instance $1830 r0 *1 1070.58,23.17 ppolyf_u
R$1830 \$74 \$76 GND_LOGIC 66666.6666667 ppolyf_u
* device instance $1831 r0 *1 1151.92,23.17 ppolyf_u
R$1831 \$76 \$78 GND_LOGIC 66666.6666667 ppolyf_u
* device instance $1832 r0 *1 1233.26,23.17 ppolyf_u
R$1832 \$78 \$81 GND_LOGIC 66666.6666667 ppolyf_u
* device instance $1833 r0 *1 1314.6,23.17 ppolyf_u
R$1833 \$81 \$82 GND_LOGIC 66666.6666667 ppolyf_u
* device instance $1834 r0 *1 1395.94,23.17 ppolyf_u
R$1834 \$82 \$84 GND_LOGIC 66666.6666667 ppolyf_u
* device instance $1835 r0 *1 1477.28,23.17 ppolyf_u
R$1835 \$84 \$86 GND_LOGIC 66666.6666667 ppolyf_u
* device instance $1836 r0 *1 1558.62,23.17 ppolyf_u
R$1836 \$86 \$72 GND_LOGIC 66666.6666667 ppolyf_u
* device instance $1837 r0 *1 989.24,23.99 ppolyf_u
R$1837 \$73 \$75 GND_LOGIC 66666.6666667 ppolyf_u
* device instance $1838 r0 *1 1070.58,23.99 ppolyf_u
R$1838 \$75 \$77 GND_LOGIC 66666.6666667 ppolyf_u
* device instance $1839 r0 *1 1151.92,23.99 ppolyf_u
R$1839 \$77 \$79 GND_LOGIC 66666.6666667 ppolyf_u
* device instance $1840 r0 *1 1233.26,23.99 ppolyf_u
R$1840 \$79 \$80 GND_LOGIC 66666.6666667 ppolyf_u
* device instance $1841 r0 *1 1314.6,23.99 ppolyf_u
R$1841 \$80 \$83 GND_LOGIC 66666.6666667 ppolyf_u
* device instance $1842 r0 *1 1395.94,23.99 ppolyf_u
R$1842 \$83 \$85 GND_LOGIC 66666.6666667 ppolyf_u
* device instance $1843 r0 *1 1477.28,23.99 ppolyf_u
R$1843 \$85 \$87 GND_LOGIC 66666.6666667 ppolyf_u
* device instance $1844 r0 *1 1558.62,23.99 ppolyf_u
R$1844 \$87 \$88 GND_LOGIC 66666.6666667 ppolyf_u
* device instance $1845 r0 *1 989.24,24.81 ppolyf_u
R$1845 \$89 \$90 GND_LOGIC 66666.6666667 ppolyf_u
* device instance $1846 r0 *1 989.24,25.63 ppolyf_u
R$1846 \$89 \$91 GND_LOGIC 66666.6666667 ppolyf_u
* device instance $1847 r0 *1 1070.58,24.81 ppolyf_u
R$1847 \$90 \$93 GND_LOGIC 66666.6666667 ppolyf_u
* device instance $1848 r0 *1 1070.58,25.63 ppolyf_u
R$1848 \$91 \$94 GND_LOGIC 66666.6666667 ppolyf_u
* device instance $1849 r0 *1 1151.92,24.81 ppolyf_u
R$1849 \$93 \$96 GND_LOGIC 66666.6666667 ppolyf_u
* device instance $1850 r0 *1 1151.92,25.63 ppolyf_u
R$1850 \$94 \$97 GND_LOGIC 66666.6666667 ppolyf_u
* device instance $1851 r0 *1 1233.26,24.81 ppolyf_u
R$1851 \$96 \$100 GND_LOGIC 66666.6666667 ppolyf_u
* device instance $1852 r0 *1 1233.26,25.63 ppolyf_u
R$1852 \$97 \$99 GND_LOGIC 66666.6666667 ppolyf_u
* device instance $1853 r0 *1 1314.6,25.63 ppolyf_u
R$1853 \$99 \$102 GND_LOGIC 66666.6666667 ppolyf_u
* device instance $1854 r0 *1 1314.6,24.81 ppolyf_u
R$1854 \$100 \$103 GND_LOGIC 66666.6666667 ppolyf_u
* device instance $1855 r0 *1 1395.94,24.81 ppolyf_u
R$1855 \$103 \$105 GND_LOGIC 66666.6666667 ppolyf_u
* device instance $1856 r0 *1 1395.94,25.63 ppolyf_u
R$1856 \$102 \$106 GND_LOGIC 66666.6666667 ppolyf_u
* device instance $1857 r0 *1 1477.28,24.81 ppolyf_u
R$1857 \$105 \$108 GND_LOGIC 66666.6666667 ppolyf_u
* device instance $1858 r0 *1 1477.28,25.63 ppolyf_u
R$1858 \$106 \$109 GND_LOGIC 66666.6666667 ppolyf_u
* device instance $1859 r0 *1 1558.62,24.81 ppolyf_u
R$1859 \$108 \$88 GND_LOGIC 66666.6666667 ppolyf_u
* device instance $1860 r0 *1 1558.62,25.63 ppolyf_u
R$1860 \$109 \$111 GND_LOGIC 66666.6666667 ppolyf_u
* device instance $1861 r0 *1 989.24,27.27 ppolyf_u
R$1861 \$112 \$113 GND_LOGIC 66666.6666667 ppolyf_u
* device instance $1862 r0 *1 989.24,26.45 ppolyf_u
R$1862 \$112 \$92 GND_LOGIC 66666.6666667 ppolyf_u
* device instance $1863 r0 *1 1070.58,27.27 ppolyf_u
R$1863 \$113 \$115 GND_LOGIC 66666.6666667 ppolyf_u
* device instance $1864 r0 *1 1070.58,26.45 ppolyf_u
R$1864 \$92 \$95 GND_LOGIC 66666.6666667 ppolyf_u
* device instance $1865 r0 *1 1151.92,27.27 ppolyf_u
R$1865 \$115 \$117 GND_LOGIC 66666.6666667 ppolyf_u
* device instance $1866 r0 *1 1151.92,26.45 ppolyf_u
R$1866 \$95 \$98 GND_LOGIC 66666.6666667 ppolyf_u
* device instance $1867 r0 *1 1233.26,26.45 ppolyf_u
R$1867 \$98 \$101 GND_LOGIC 66666.6666667 ppolyf_u
* device instance $1868 r0 *1 1233.26,27.27 ppolyf_u
R$1868 \$117 \$119 GND_LOGIC 66666.6666667 ppolyf_u
* device instance $1869 r0 *1 1314.6,27.27 ppolyf_u
R$1869 \$119 \$121 GND_LOGIC 66666.6666667 ppolyf_u
* device instance $1870 r0 *1 1314.6,26.45 ppolyf_u
R$1870 \$101 \$104 GND_LOGIC 66666.6666667 ppolyf_u
* device instance $1871 r0 *1 1395.94,26.45 ppolyf_u
R$1871 \$104 \$107 GND_LOGIC 66666.6666667 ppolyf_u
* device instance $1872 r0 *1 1395.94,27.27 ppolyf_u
R$1872 \$121 \$123 GND_LOGIC 66666.6666667 ppolyf_u
* device instance $1873 r0 *1 1477.28,26.45 ppolyf_u
R$1873 \$107 \$110 GND_LOGIC 66666.6666667 ppolyf_u
* device instance $1874 r0 *1 1477.28,27.27 ppolyf_u
R$1874 \$123 \$125 GND_LOGIC 66666.6666667 ppolyf_u
* device instance $1875 r0 *1 1558.62,27.27 ppolyf_u
R$1875 \$125 \$127 GND_LOGIC 66666.6666667 ppolyf_u
* device instance $1876 r0 *1 1558.62,26.45 ppolyf_u
R$1876 \$110 \$111 GND_LOGIC 66666.6666667 ppolyf_u
* device instance $1877 r0 *1 989.24,28.09 ppolyf_u
R$1877 \$128 \$114 GND_LOGIC 66666.6666667 ppolyf_u
* device instance $1878 r0 *1 989.24,28.91 ppolyf_u
R$1878 \$128 \$129 GND_LOGIC 66666.6666667 ppolyf_u
* device instance $1879 r0 *1 1070.58,28.09 ppolyf_u
R$1879 \$114 \$116 GND_LOGIC 66666.6666667 ppolyf_u
* device instance $1880 r0 *1 1070.58,28.91 ppolyf_u
R$1880 \$129 \$131 GND_LOGIC 66666.6666667 ppolyf_u
* device instance $1881 r0 *1 1151.92,28.91 ppolyf_u
R$1881 \$131 \$133 GND_LOGIC 66666.6666667 ppolyf_u
* device instance $1882 r0 *1 1151.92,28.09 ppolyf_u
R$1882 \$116 \$118 GND_LOGIC 66666.6666667 ppolyf_u
* device instance $1883 r0 *1 1233.26,28.09 ppolyf_u
R$1883 \$118 \$120 GND_LOGIC 66666.6666667 ppolyf_u
* device instance $1884 r0 *1 1233.26,28.91 ppolyf_u
R$1884 \$133 \$135 GND_LOGIC 66666.6666667 ppolyf_u
* device instance $1885 r0 *1 1314.6,28.91 ppolyf_u
R$1885 \$135 \$137 GND_LOGIC 66666.6666667 ppolyf_u
* device instance $1886 r0 *1 1314.6,28.09 ppolyf_u
R$1886 \$120 \$122 GND_LOGIC 66666.6666667 ppolyf_u
* device instance $1887 r0 *1 1395.94,28.91 ppolyf_u
R$1887 \$137 \$139 GND_LOGIC 66666.6666667 ppolyf_u
* device instance $1888 r0 *1 1395.94,28.09 ppolyf_u
R$1888 \$122 \$124 GND_LOGIC 66666.6666667 ppolyf_u
* device instance $1889 r0 *1 1477.28,28.91 ppolyf_u
R$1889 \$139 \$141 GND_LOGIC 66666.6666667 ppolyf_u
* device instance $1890 r0 *1 1477.28,28.09 ppolyf_u
R$1890 \$124 \$126 GND_LOGIC 66666.6666667 ppolyf_u
* device instance $1891 r0 *1 1558.62,28.91 ppolyf_u
R$1891 \$141 \$143 GND_LOGIC 66666.6666667 ppolyf_u
* device instance $1892 r0 *1 1558.62,28.09 ppolyf_u
R$1892 \$126 \$127 GND_LOGIC 66666.6666667 ppolyf_u
* device instance $1893 r0 *1 989.24,29.73 ppolyf_u
R$1893 \$144 \$130 GND_LOGIC 66666.6666667 ppolyf_u
* device instance $1894 r0 *1 989.24,30.55 ppolyf_u
R$1894 \$144 \$145 GND_LOGIC 66666.6666667 ppolyf_u
* device instance $1895 r0 *1 1070.58,30.55 ppolyf_u
R$1895 \$145 \$147 GND_LOGIC 66666.6666667 ppolyf_u
* device instance $1896 r0 *1 1070.58,29.73 ppolyf_u
R$1896 \$130 \$132 GND_LOGIC 66666.6666667 ppolyf_u
* device instance $1897 r0 *1 1151.92,29.73 ppolyf_u
R$1897 \$132 \$134 GND_LOGIC 66666.6666667 ppolyf_u
* device instance $1898 r0 *1 1151.92,30.55 ppolyf_u
R$1898 \$147 \$149 GND_LOGIC 66666.6666667 ppolyf_u
* device instance $1899 r0 *1 1233.26,30.55 ppolyf_u
R$1899 \$149 \$151 GND_LOGIC 66666.6666667 ppolyf_u
* device instance $1900 r0 *1 1233.26,29.73 ppolyf_u
R$1900 \$134 \$136 GND_LOGIC 66666.6666667 ppolyf_u
* device instance $1901 r0 *1 1314.6,29.73 ppolyf_u
R$1901 \$136 \$138 GND_LOGIC 66666.6666667 ppolyf_u
* device instance $1902 r0 *1 1314.6,30.55 ppolyf_u
R$1902 \$151 \$153 GND_LOGIC 66666.6666667 ppolyf_u
* device instance $1903 r0 *1 1395.94,30.55 ppolyf_u
R$1903 \$153 \$155 GND_LOGIC 66666.6666667 ppolyf_u
* device instance $1904 r0 *1 1395.94,29.73 ppolyf_u
R$1904 \$138 \$140 GND_LOGIC 66666.6666667 ppolyf_u
* device instance $1905 r0 *1 1477.28,30.55 ppolyf_u
R$1905 \$155 \$157 GND_LOGIC 66666.6666667 ppolyf_u
* device instance $1906 r0 *1 1477.28,29.73 ppolyf_u
R$1906 \$140 \$142 GND_LOGIC 66666.6666667 ppolyf_u
* device instance $1907 r0 *1 1558.62,30.55 ppolyf_u
R$1907 \$157 \$159 GND_LOGIC 66666.6666667 ppolyf_u
* device instance $1908 r0 *1 1558.62,29.73 ppolyf_u
R$1908 \$142 \$143 GND_LOGIC 66666.6666667 ppolyf_u
* device instance $1909 r0 *1 989.24,31.37 ppolyf_u
R$1909 \$160 \$146 GND_LOGIC 66666.6666667 ppolyf_u
* device instance $1910 r0 *1 989.24,32.19 ppolyf_u
R$1910 \$160 \$161 GND_LOGIC 66666.6666667 ppolyf_u
* device instance $1911 r0 *1 1070.58,32.19 ppolyf_u
R$1911 \$161 \$163 GND_LOGIC 66666.6666667 ppolyf_u
* device instance $1912 r0 *1 1070.58,31.37 ppolyf_u
R$1912 \$146 \$148 GND_LOGIC 66666.6666667 ppolyf_u
* device instance $1913 r0 *1 1151.92,32.19 ppolyf_u
R$1913 \$163 \$165 GND_LOGIC 66666.6666667 ppolyf_u
* device instance $1914 r0 *1 1151.92,31.37 ppolyf_u
R$1914 \$148 \$150 GND_LOGIC 66666.6666667 ppolyf_u
* device instance $1915 r0 *1 1233.26,31.37 ppolyf_u
R$1915 \$150 \$152 GND_LOGIC 66666.6666667 ppolyf_u
* device instance $1916 r0 *1 1233.26,32.19 ppolyf_u
R$1916 \$165 \$167 GND_LOGIC 66666.6666667 ppolyf_u
* device instance $1917 r0 *1 1314.6,31.37 ppolyf_u
R$1917 \$152 \$154 GND_LOGIC 66666.6666667 ppolyf_u
* device instance $1918 r0 *1 1314.6,32.19 ppolyf_u
R$1918 \$167 \$169 GND_LOGIC 66666.6666667 ppolyf_u
* device instance $1919 r0 *1 1395.94,32.19 ppolyf_u
R$1919 \$169 \$171 GND_LOGIC 66666.6666667 ppolyf_u
* device instance $1920 r0 *1 1395.94,31.37 ppolyf_u
R$1920 \$154 \$156 GND_LOGIC 66666.6666667 ppolyf_u
* device instance $1921 r0 *1 1477.28,31.37 ppolyf_u
R$1921 \$156 \$158 GND_LOGIC 66666.6666667 ppolyf_u
* device instance $1922 r0 *1 1477.28,32.19 ppolyf_u
R$1922 \$171 \$173 GND_LOGIC 66666.6666667 ppolyf_u
* device instance $1923 r0 *1 1558.62,32.19 ppolyf_u
R$1923 \$173 \$175 GND_LOGIC 66666.6666667 ppolyf_u
* device instance $1924 r0 *1 1558.62,31.37 ppolyf_u
R$1924 \$158 \$159 GND_LOGIC 66666.6666667 ppolyf_u
* device instance $1925 r0 *1 989.24,33.01 ppolyf_u
R$1925 \$176 \$162 GND_LOGIC 66666.6666667 ppolyf_u
* device instance $1926 r0 *1 989.24,33.83 ppolyf_u
R$1926 \$176 \$177 GND_LOGIC 66666.6666667 ppolyf_u
* device instance $1927 r0 *1 1070.58,33.01 ppolyf_u
R$1927 \$162 \$164 GND_LOGIC 66666.6666667 ppolyf_u
* device instance $1928 r0 *1 1070.58,33.83 ppolyf_u
R$1928 \$177 \$179 GND_LOGIC 66666.6666667 ppolyf_u
* device instance $1929 r0 *1 1151.92,33.83 ppolyf_u
R$1929 \$179 \$181 GND_LOGIC 66666.6666667 ppolyf_u
* device instance $1930 r0 *1 1151.92,33.01 ppolyf_u
R$1930 \$164 \$166 GND_LOGIC 66666.6666667 ppolyf_u
* device instance $1931 r0 *1 1233.26,33.01 ppolyf_u
R$1931 \$166 \$168 GND_LOGIC 66666.6666667 ppolyf_u
* device instance $1932 r0 *1 1233.26,33.83 ppolyf_u
R$1932 \$181 \$183 GND_LOGIC 66666.6666667 ppolyf_u
* device instance $1933 r0 *1 1314.6,33.01 ppolyf_u
R$1933 \$168 \$170 GND_LOGIC 66666.6666667 ppolyf_u
* device instance $1934 r0 *1 1314.6,33.83 ppolyf_u
R$1934 \$183 \$185 GND_LOGIC 66666.6666667 ppolyf_u
* device instance $1935 r0 *1 1395.94,33.83 ppolyf_u
R$1935 \$185 \$187 GND_LOGIC 66666.6666667 ppolyf_u
* device instance $1936 r0 *1 1395.94,33.01 ppolyf_u
R$1936 \$170 \$172 GND_LOGIC 66666.6666667 ppolyf_u
* device instance $1937 r0 *1 1477.28,33.01 ppolyf_u
R$1937 \$172 \$174 GND_LOGIC 66666.6666667 ppolyf_u
* device instance $1938 r0 *1 1477.28,33.83 ppolyf_u
R$1938 \$187 \$189 GND_LOGIC 66666.6666667 ppolyf_u
* device instance $1939 r0 *1 1558.62,33.83 ppolyf_u
R$1939 \$189 \$191 GND_LOGIC 66666.6666667 ppolyf_u
* device instance $1940 r0 *1 1558.62,33.01 ppolyf_u
R$1940 \$174 \$175 GND_LOGIC 66666.6666667 ppolyf_u
* device instance $1941 r0 *1 989.24,35.47 ppolyf_u
R$1941 \$192 \$193 GND_LOGIC 66666.6666667 ppolyf_u
* device instance $1942 r0 *1 989.24,34.65 ppolyf_u
R$1942 \$192 \$178 GND_LOGIC 66666.6666667 ppolyf_u
* device instance $1943 r0 *1 1070.58,35.47 ppolyf_u
R$1943 \$193 \$195 GND_LOGIC 66666.6666667 ppolyf_u
* device instance $1944 r0 *1 1070.58,34.65 ppolyf_u
R$1944 \$178 \$180 GND_LOGIC 66666.6666667 ppolyf_u
* device instance $1945 r0 *1 1151.92,34.65 ppolyf_u
R$1945 \$180 \$182 GND_LOGIC 66666.6666667 ppolyf_u
* device instance $1946 r0 *1 1151.92,35.47 ppolyf_u
R$1946 \$195 \$197 GND_LOGIC 66666.6666667 ppolyf_u
* device instance $1947 r0 *1 1233.26,34.65 ppolyf_u
R$1947 \$182 \$184 GND_LOGIC 66666.6666667 ppolyf_u
* device instance $1948 r0 *1 1233.26,35.47 ppolyf_u
R$1948 \$197 \$199 GND_LOGIC 66666.6666667 ppolyf_u
* device instance $1949 r0 *1 1314.6,35.47 ppolyf_u
R$1949 \$199 \$201 GND_LOGIC 66666.6666667 ppolyf_u
* device instance $1950 r0 *1 1314.6,34.65 ppolyf_u
R$1950 \$184 \$186 GND_LOGIC 66666.6666667 ppolyf_u
* device instance $1951 r0 *1 1395.94,34.65 ppolyf_u
R$1951 \$186 \$188 GND_LOGIC 66666.6666667 ppolyf_u
* device instance $1952 r0 *1 1395.94,35.47 ppolyf_u
R$1952 \$201 \$203 GND_LOGIC 66666.6666667 ppolyf_u
* device instance $1953 r0 *1 1477.28,34.65 ppolyf_u
R$1953 \$188 \$190 GND_LOGIC 66666.6666667 ppolyf_u
* device instance $1954 r0 *1 1477.28,35.47 ppolyf_u
R$1954 \$203 \$205 GND_LOGIC 66666.6666667 ppolyf_u
* device instance $1955 r0 *1 1558.62,35.47 ppolyf_u
R$1955 \$205 \$207 GND_LOGIC 66666.6666667 ppolyf_u
* device instance $1956 r0 *1 1558.62,34.65 ppolyf_u
R$1956 \$190 \$191 GND_LOGIC 66666.6666667 ppolyf_u
* device instance $1957 r0 *1 989.24,37.11 ppolyf_u
R$1957 \$208 \$209 GND_LOGIC 66666.6666667 ppolyf_u
* device instance $1958 r0 *1 989.24,36.29 ppolyf_u
R$1958 \$208 \$194 GND_LOGIC 66666.6666667 ppolyf_u
* device instance $1959 r0 *1 1070.58,37.11 ppolyf_u
R$1959 \$209 \$211 GND_LOGIC 66666.6666667 ppolyf_u
* device instance $1960 r0 *1 1070.58,36.29 ppolyf_u
R$1960 \$194 \$196 GND_LOGIC 66666.6666667 ppolyf_u
* device instance $1961 r0 *1 1151.92,36.29 ppolyf_u
R$1961 \$196 \$198 GND_LOGIC 66666.6666667 ppolyf_u
* device instance $1962 r0 *1 1151.92,37.11 ppolyf_u
R$1962 \$211 \$213 GND_LOGIC 66666.6666667 ppolyf_u
* device instance $1963 r0 *1 1233.26,37.11 ppolyf_u
R$1963 \$213 \$215 GND_LOGIC 66666.6666667 ppolyf_u
* device instance $1964 r0 *1 1233.26,36.29 ppolyf_u
R$1964 \$198 \$200 GND_LOGIC 66666.6666667 ppolyf_u
* device instance $1965 r0 *1 1314.6,36.29 ppolyf_u
R$1965 \$200 \$202 GND_LOGIC 66666.6666667 ppolyf_u
* device instance $1966 r0 *1 1314.6,37.11 ppolyf_u
R$1966 \$215 \$217 GND_LOGIC 66666.6666667 ppolyf_u
* device instance $1967 r0 *1 1395.94,37.11 ppolyf_u
R$1967 \$217 \$219 GND_LOGIC 66666.6666667 ppolyf_u
* device instance $1968 r0 *1 1395.94,36.29 ppolyf_u
R$1968 \$202 \$204 GND_LOGIC 66666.6666667 ppolyf_u
* device instance $1969 r0 *1 1477.28,37.11 ppolyf_u
R$1969 \$219 \$221 GND_LOGIC 66666.6666667 ppolyf_u
* device instance $1970 r0 *1 1477.28,36.29 ppolyf_u
R$1970 \$204 \$206 GND_LOGIC 66666.6666667 ppolyf_u
* device instance $1971 r0 *1 1558.62,36.29 ppolyf_u
R$1971 \$206 \$207 GND_LOGIC 66666.6666667 ppolyf_u
* device instance $1972 r0 *1 1558.62,37.11 ppolyf_u
R$1972 \$221 \$223 GND_LOGIC 66666.6666667 ppolyf_u
* device instance $1973 r0 *1 989.24,37.93 ppolyf_u
R$1973 \$224 \$210 GND_LOGIC 66666.6666667 ppolyf_u
* device instance $1974 r0 *1 989.24,38.75 ppolyf_u
R$1974 \$224 \$225 GND_LOGIC 66666.6666667 ppolyf_u
* device instance $1975 r0 *1 1070.58,38.75 ppolyf_u
R$1975 \$225 \$227 GND_LOGIC 66666.6666667 ppolyf_u
* device instance $1976 r0 *1 1070.58,37.93 ppolyf_u
R$1976 \$210 \$212 GND_LOGIC 66666.6666667 ppolyf_u
* device instance $1977 r0 *1 1151.92,37.93 ppolyf_u
R$1977 \$212 \$214 GND_LOGIC 66666.6666667 ppolyf_u
* device instance $1978 r0 *1 1151.92,38.75 ppolyf_u
R$1978 \$227 \$229 GND_LOGIC 66666.6666667 ppolyf_u
* device instance $1979 r0 *1 1233.26,38.75 ppolyf_u
R$1979 \$229 \$231 GND_LOGIC 66666.6666667 ppolyf_u
* device instance $1980 r0 *1 1233.26,37.93 ppolyf_u
R$1980 \$214 \$216 GND_LOGIC 66666.6666667 ppolyf_u
* device instance $1981 r0 *1 1314.6,37.93 ppolyf_u
R$1981 \$216 \$218 GND_LOGIC 66666.6666667 ppolyf_u
* device instance $1982 r0 *1 1314.6,38.75 ppolyf_u
R$1982 \$231 \$233 GND_LOGIC 66666.6666667 ppolyf_u
* device instance $1983 r0 *1 1395.94,38.75 ppolyf_u
R$1983 \$233 \$235 GND_LOGIC 66666.6666667 ppolyf_u
* device instance $1984 r0 *1 1395.94,37.93 ppolyf_u
R$1984 \$218 \$220 GND_LOGIC 66666.6666667 ppolyf_u
* device instance $1985 r0 *1 1477.28,38.75 ppolyf_u
R$1985 \$235 \$237 GND_LOGIC 66666.6666667 ppolyf_u
* device instance $1986 r0 *1 1477.28,37.93 ppolyf_u
R$1986 \$220 \$222 GND_LOGIC 66666.6666667 ppolyf_u
* device instance $1987 r0 *1 1558.62,37.93 ppolyf_u
R$1987 \$222 \$223 GND_LOGIC 66666.6666667 ppolyf_u
* device instance $1988 r0 *1 1558.62,38.75 ppolyf_u
R$1988 \$237 \$239 GND_LOGIC 66666.6666667 ppolyf_u
* device instance $1989 r0 *1 989.24,40.39 ppolyf_u
R$1989 \$240 \$241 GND_LOGIC 66666.6666667 ppolyf_u
* device instance $1990 r0 *1 989.24,39.57 ppolyf_u
R$1990 \$240 \$226 GND_LOGIC 66666.6666667 ppolyf_u
* device instance $1991 r0 *1 1070.58,40.39 ppolyf_u
R$1991 \$241 \$243 GND_LOGIC 66666.6666667 ppolyf_u
* device instance $1992 r0 *1 1070.58,39.57 ppolyf_u
R$1992 \$226 \$228 GND_LOGIC 66666.6666667 ppolyf_u
* device instance $1993 r0 *1 1151.92,39.57 ppolyf_u
R$1993 \$228 \$230 GND_LOGIC 66666.6666667 ppolyf_u
* device instance $1994 r0 *1 1151.92,40.39 ppolyf_u
R$1994 \$243 \$245 GND_LOGIC 66666.6666667 ppolyf_u
* device instance $1995 r0 *1 1233.26,40.39 ppolyf_u
R$1995 \$245 \$247 GND_LOGIC 66666.6666667 ppolyf_u
* device instance $1996 r0 *1 1233.26,39.57 ppolyf_u
R$1996 \$230 \$232 GND_LOGIC 66666.6666667 ppolyf_u
* device instance $1997 r0 *1 1314.6,40.39 ppolyf_u
R$1997 \$247 \$249 GND_LOGIC 66666.6666667 ppolyf_u
* device instance $1998 r0 *1 1314.6,39.57 ppolyf_u
R$1998 \$232 \$234 GND_LOGIC 66666.6666667 ppolyf_u
* device instance $1999 r0 *1 1395.94,39.57 ppolyf_u
R$1999 \$234 \$236 GND_LOGIC 66666.6666667 ppolyf_u
* device instance $2000 r0 *1 1395.94,40.39 ppolyf_u
R$2000 \$249 \$251 GND_LOGIC 66666.6666667 ppolyf_u
* device instance $2001 r0 *1 1477.28,40.39 ppolyf_u
R$2001 \$251 \$253 GND_LOGIC 66666.6666667 ppolyf_u
* device instance $2002 r0 *1 1477.28,39.57 ppolyf_u
R$2002 \$236 \$238 GND_LOGIC 66666.6666667 ppolyf_u
* device instance $2003 r0 *1 1558.62,40.39 ppolyf_u
R$2003 \$253 \$255 GND_LOGIC 66666.6666667 ppolyf_u
* device instance $2004 r0 *1 1558.62,39.57 ppolyf_u
R$2004 \$238 \$239 GND_LOGIC 66666.6666667 ppolyf_u
* device instance $2005 r0 *1 989.24,41.21 ppolyf_u
R$2005 \$256 \$242 GND_LOGIC 66666.6666667 ppolyf_u
* device instance $2006 r0 *1 989.24,42.03 ppolyf_u
R$2006 \$256 \$257 GND_LOGIC 66666.6666667 ppolyf_u
* device instance $2007 r0 *1 1070.58,41.21 ppolyf_u
R$2007 \$242 \$244 GND_LOGIC 66666.6666667 ppolyf_u
* device instance $2008 r0 *1 1070.58,42.03 ppolyf_u
R$2008 \$257 \$259 GND_LOGIC 66666.6666667 ppolyf_u
* device instance $2009 r0 *1 1151.92,42.03 ppolyf_u
R$2009 \$259 \$261 GND_LOGIC 66666.6666667 ppolyf_u
* device instance $2010 r0 *1 1151.92,41.21 ppolyf_u
R$2010 \$244 \$246 GND_LOGIC 66666.6666667 ppolyf_u
* device instance $2011 r0 *1 1233.26,42.03 ppolyf_u
R$2011 \$261 \$263 GND_LOGIC 66666.6666667 ppolyf_u
* device instance $2012 r0 *1 1233.26,41.21 ppolyf_u
R$2012 \$246 \$248 GND_LOGIC 66666.6666667 ppolyf_u
* device instance $2013 r0 *1 1314.6,42.03 ppolyf_u
R$2013 \$263 \$265 GND_LOGIC 66666.6666667 ppolyf_u
* device instance $2014 r0 *1 1314.6,41.21 ppolyf_u
R$2014 \$248 \$250 GND_LOGIC 66666.6666667 ppolyf_u
* device instance $2015 r0 *1 1395.94,41.21 ppolyf_u
R$2015 \$250 \$252 GND_LOGIC 66666.6666667 ppolyf_u
* device instance $2016 r0 *1 1395.94,42.03 ppolyf_u
R$2016 \$265 \$267 GND_LOGIC 66666.6666667 ppolyf_u
* device instance $2017 r0 *1 1477.28,42.03 ppolyf_u
R$2017 \$267 \$269 GND_LOGIC 66666.6666667 ppolyf_u
* device instance $2018 r0 *1 1477.28,41.21 ppolyf_u
R$2018 \$252 \$254 GND_LOGIC 66666.6666667 ppolyf_u
* device instance $2019 r0 *1 1558.62,41.21 ppolyf_u
R$2019 \$254 \$255 GND_LOGIC 66666.6666667 ppolyf_u
* device instance $2020 r0 *1 1558.62,42.03 ppolyf_u
R$2020 \$269 \$271 GND_LOGIC 66666.6666667 ppolyf_u
* device instance $2021 r0 *1 989.24,43.67 ppolyf_u
R$2021 \$272 \$273 GND_LOGIC 66666.6666667 ppolyf_u
* device instance $2022 r0 *1 989.24,42.85 ppolyf_u
R$2022 \$272 \$258 GND_LOGIC 66666.6666667 ppolyf_u
* device instance $2023 r0 *1 1070.58,43.67 ppolyf_u
R$2023 \$273 \$275 GND_LOGIC 66666.6666667 ppolyf_u
* device instance $2024 r0 *1 1070.58,42.85 ppolyf_u
R$2024 \$258 \$260 GND_LOGIC 66666.6666667 ppolyf_u
* device instance $2025 r0 *1 1151.92,42.85 ppolyf_u
R$2025 \$260 \$262 GND_LOGIC 66666.6666667 ppolyf_u
* device instance $2026 r0 *1 1151.92,43.67 ppolyf_u
R$2026 \$275 \$277 GND_LOGIC 66666.6666667 ppolyf_u
* device instance $2027 r0 *1 1233.26,43.67 ppolyf_u
R$2027 \$277 \$279 GND_LOGIC 66666.6666667 ppolyf_u
* device instance $2028 r0 *1 1233.26,42.85 ppolyf_u
R$2028 \$262 \$264 GND_LOGIC 66666.6666667 ppolyf_u
* device instance $2029 r0 *1 1314.6,43.67 ppolyf_u
R$2029 \$279 \$281 GND_LOGIC 66666.6666667 ppolyf_u
* device instance $2030 r0 *1 1314.6,42.85 ppolyf_u
R$2030 \$264 \$266 GND_LOGIC 66666.6666667 ppolyf_u
* device instance $2031 r0 *1 1395.94,42.85 ppolyf_u
R$2031 \$266 \$268 GND_LOGIC 66666.6666667 ppolyf_u
* device instance $2032 r0 *1 1395.94,43.67 ppolyf_u
R$2032 \$281 \$283 GND_LOGIC 66666.6666667 ppolyf_u
* device instance $2033 r0 *1 1477.28,43.67 ppolyf_u
R$2033 \$283 \$285 GND_LOGIC 66666.6666667 ppolyf_u
* device instance $2034 r0 *1 1477.28,42.85 ppolyf_u
R$2034 \$268 \$270 GND_LOGIC 66666.6666667 ppolyf_u
* device instance $2035 r0 *1 1558.62,43.67 ppolyf_u
R$2035 \$285 \$287 GND_LOGIC 66666.6666667 ppolyf_u
* device instance $2036 r0 *1 1558.62,42.85 ppolyf_u
R$2036 \$270 \$271 GND_LOGIC 66666.6666667 ppolyf_u
* device instance $2037 r0 *1 989.24,44.49 ppolyf_u
R$2037 x3_ndiv \$274 GND_LOGIC 66666.6666667 ppolyf_u
* device instance $2038 r0 *1 1070.58,44.49 ppolyf_u
R$2038 \$274 \$276 GND_LOGIC 66666.6666667 ppolyf_u
* device instance $2039 r0 *1 1151.92,44.49 ppolyf_u
R$2039 \$276 \$278 GND_LOGIC 66666.6666667 ppolyf_u
* device instance $2040 r0 *1 1233.26,44.49 ppolyf_u
R$2040 \$278 \$280 GND_LOGIC 66666.6666667 ppolyf_u
* device instance $2041 r0 *1 1314.6,44.49 ppolyf_u
R$2041 \$280 \$282 GND_LOGIC 66666.6666667 ppolyf_u
* device instance $2042 r0 *1 1395.94,44.49 ppolyf_u
R$2042 \$282 \$284 GND_LOGIC 66666.6666667 ppolyf_u
* device instance $2043 r0 *1 1477.28,44.49 ppolyf_u
R$2043 \$284 \$286 GND_LOGIC 66666.6666667 ppolyf_u
* device instance $2044 r0 *1 1558.62,44.49 ppolyf_u
R$2044 \$286 \$287 GND_LOGIC 66666.6666667 ppolyf_u
.ENDS gate_driver_core
