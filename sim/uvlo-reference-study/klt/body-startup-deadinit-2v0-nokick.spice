* startup grid NEGATIVE CONTROL: dead-initialised, MKICK deleted, 2.0 V.
* issue #556, decision record 0024 adoption gate 3 -- one stimulus of the
* startup-path grid (see ../README.md "Gate 3: startup path"). Copies of
* body-bandgap-trip.spice's boundary condition: same DUT include (../uvlo_bandgap_ref_nokick.spice),
* same 100k pull-up rpu + 6 fF on OUT, no models/.lib/.temp/.control/.end --
* klt owns those. .options reltol=1e-4 is carried here, not in
* options.ngspice_options: the batch fleet's runner drops that request field.
*
* Stimulus: identical to body-startup-deadinit-2v0.spice except the DUT include: the
* negative-control netlist whose XMKICK is deleted. This is record 0024's
* measured unsafe case (settled nvref 0.117 V, lockout LOW at 2 V, 27 C);
* the same checks that pass the MKICK-present grid must FAIL it.
.options reltol=1e-4

.include "design.ngspice"
.include "../uvlo_bandgap_ref_nokick.spice"

vsup VDD_DRV 0 dc 2
vgnd GND_DRV 0 dc 0
rpu VDD_DRV OUT 100k
cload OUT GND_DRV 6f
