* startup grid, brown-out and re-ramp from a partially discharged rail.
* issue #556, decision record 0024 adoption gate 3 -- one stimulus of the
* startup-path grid (see ../README.md "Gate 3: startup path"). Copies of
* body-bandgap-trip.spice's boundary condition: same DUT include (../uvlo_bandgap_ref.spice),
* same 100k pull-up rpu + 6 fF on OUT, no models/.lib/.temp/.control/.end --
* klt owns those. .options reltol=1e-4 is carried here, not in
* options.ngspice_options: the batch fleet's runner drops that request field.
*
* Stimulus: 0 -> 6 V (20 us), hold to 60 us; 6 -> 1.5 V in 1 ns (body-response.spice's
* edge rate -- 1.5 V is below the core's regulation headroom but not 0, the
* partial-discharge state); hold 1.5 V to 110 us; re-ramp 1.5 -> 6 V over
* 20 us; hold to 180 us. OUT must stay low through the hold and the re-ramp
* release must sit at/above the falling-window floor.
.options reltol=1e-4

.include "design.ngspice"
.include "../uvlo_bandgap_ref.spice"

vsup VDD_DRV 0 pwl(0 0 20u 6 60u 6 60.000001u 1.5 110u 1.5 130u 6 180u 6)
vgnd GND_DRV 0 dc 0
rpu VDD_DRV OUT 100k
cload OUT GND_DRV 6f
