* startup grid, power-on to a normal 5.0 V rail.
* issue #556, decision record 0024 adoption gate 3 -- one stimulus of the
* startup-path grid (see ../README.md "Gate 3: startup path"). Copies of
* body-bandgap-trip.spice's boundary condition: same DUT include (../uvlo_bandgap_ref.spice),
* same 100k pull-up rpu + 6 fF on OUT, no models/.lib/.temp/.control/.end --
* klt owns those. .options reltol=1e-4 is carried here, not in
* options.ngspice_options: the batch fleet's runner drops that request field.
*
* Stimulus: pwl 0 -> 5 V over 20 us, then hold 5 V to 220 us. 5 V is above every
* corner's rising trip, so the settled state must be RELEASED (lockout low)
* with the core alive -- the 0024 5 V row, now at 15 corners.
.options reltol=1e-4

.include "design.ngspice"
.include "../uvlo_bandgap_ref.spice"

vsup VDD_DRV 0 pwl(0 0 20u 5 220u 5)
vgnd GND_DRV 0 dc 0
rpu VDD_DRV OUT 100k
cload OUT GND_DRV 6f
