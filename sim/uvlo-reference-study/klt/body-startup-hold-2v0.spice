* startup grid, power-on to a stuck 2.0 V rail (below the falling-trip
* window, the 0024 'released at 2 V' failure level).
* issue #556, decision record 0024 adoption gate 3 -- one stimulus of the
* startup-path grid (see ../README.md "Gate 3: startup path"). Copies of
* body-bandgap-trip.spice's boundary condition: same DUT include (../uvlo_bandgap_ref.spice),
* same 100k pull-up rpu + 6 fF on OUT, no models/.lib/.temp/.control/.end --
* klt owns those. .options reltol=1e-4 is carried here, not in
* options.ngspice_options: the batch fleet's runner drops that request field.
*
* Stimulus: pwl 0 -> 2 V over 20 us, then hold 2 V to 220 us. Settled `lockout` must
* be HIGH and OUT low: with MKICK deleted this exact level released OUT at
* 27 C in record 0024's table.
.options reltol=1e-4

.include "design.ngspice"
.include "../uvlo_bandgap_ref.spice"

vsup VDD_DRV 0 pwl(0 0 20u 2 220u 2)
vgnd GND_DRV 0 dc 0
rpu VDD_DRV OUT 100k
cload OUT GND_DRV 6f
