* startup grid, power-on ramp 0 -> 6 V at 200 ns per edge (very fast).
* issue #556, decision record 0024 adoption gate 3 -- one stimulus of the
* startup-path grid (see ../README.md "Gate 3: startup path"). Copies of
* body-bandgap-trip.spice's boundary condition: same DUT include (../uvlo_bandgap_ref.spice),
* same 100k pull-up rpu + 6 fF on OUT, no models/.lib/.temp/.control/.end --
* klt owns those. .options reltol=1e-4 is carried here, not in
* options.ngspice_options: the batch fleet's runner drops that request field.
*
* Stimulus: pwl 0 -> 6 V over 200 ns, then hold to 20 us. No UVLO comparator can
* assert inside a 200 ns cold ramp; graded on the settled end state only.
.options reltol=1e-4

.include "design.ngspice"
.include "../uvlo_bandgap_ref.spice"

vsup VDD_DRV 0 pwl(0 0 200n 6 20u 6)
vgnd GND_DRV 0 dc 0
rpu VDD_DRV OUT 100k
cload OUT GND_DRV 6f
