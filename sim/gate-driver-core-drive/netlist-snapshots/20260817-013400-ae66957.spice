* Frozen netlist snapshot for record 20260817-013400-ae66957
* source     : sim/gate-driver-core-drive/testbench/gate_driver_core_tb.spice
* sha256     : 40e550cde6bc25ac8c253e42c46151ce10f4d639b8cbfd12a02d1d27a8d1b058
* This is a verbatim copy taken at record time. Do not edit.
* gate-driver-core-drive -- END-TO-END stimulus + reference load for
* design/netlist/gate_driver_core.spice (issue #98's combined top-level
* netlist: design/gate_driver_core.sch instantiating x1=level_shifter,
* x2=output_stage), substantiating spec/gate-driver.md Sec.3's block-level
* drive targets against the FULL signal chain -- logic-in (IN) ->
* level_shifter -> output_stage -> 1 nF reference load -- not an isolated
* sub-cell in isolation (issue #100; the two prior per-cell PVT campaigns,
* sim/output-stage-drive/ and sim/level-shifter-oxide-safety/, each only
* cover one half of this path).
*
* Netlist FRAGMENT. The harness supplies the title, .include of the
* gf180mcu models, the corner .lib sections, .temp, this experiment's DUT
* fragment (design/netlist/gate_driver_core.spice, .include'd ahead of this
* file -- see tb.json's "dut" key), the .control block and .end.
*
* This testbench uses this repo's default two rails (vlogic 3.3V logic
* supply, vdrv 5V/6V drive rail -- tb.json omits "rails" to get
* corners.DEFAULT_RAILS), matching the block's two actual supply domains
* (design/gate_driver_core.sch's VDD_LOGIC/GND_LOGIC and VDD_DRV/GND_DRV
* pins). The harness hands this fragment, per sim/harness/README.md:
*   vlogic_val / vlogic_nom   this PVT point's VDD_LOGIC supply / 3.30V nominal
*   vdrv_val   / vdrv_nom     this PVT point's VDD_DRV supply (nominal, +-tol,
*                             or the 6V stretch point) / 5.00V nominal
*   temp_c                    temperature for this PVT point (also applied
*                             via .temp)
*
* GND_LOGIC and GND_DRV are two pins but one electrical reference node by
* design intent (decision record 0001, Decision 1: "tied together with
* minimal impedance close to the device (star point)") -- modeled here as
* a milliohm-scale tie, matching
* sim/level-shifter-oxide-safety/testbench/level_shifter_tb.spice's
* convention, not a literal short.
*
* IN is driven at the block's actual 3.3V logic input pin (not an
* already-level-shifted IN_DRV the way sim/output-stage-drive/ drives its
* isolated DUT) -- an idealized rail-to-rail pulse referenced to
* GND_LOGIC, swinging the full vlogic_val rail (0 -> vlogic_val). Starts
* low so the whole chain settles to a well-defined DC operating point
* (OUT low, level shifter + output stage both non-inverting, decision
* record 0001 Decision 3) before the first transient edge. The pulse
* width/period is generous (300 ns high, 700 ns period) relative to the
* individual per-cell records' own worst-case delays (level shifter
* t_plh/t_phl <= ~1.2 ns, sim/level-shifter-oxide-safety; output stage
* tpdlh/tpdhl <= ~8.4 ns nominal / ~5.0 ns stretch,
* sim/output-stage-drive) so the combined end-to-end edge is fully settled
* long before the next transition, at every PVT point including the
* worst-case slow corners.

* Internal-node probing (tb.json's "measure" map). Because the DUT's top
* cell is a FRAGMENT whose own `.subckt gate_driver_core` line is commented
* out (design/netlist/gate_driver_core.spice), x1/x2 are instantiated at
* this deck's top level -- so the inter-cell net IN_DRV is a plain
* top-level node, `v(IN_DRV)`, while the output stage's internal taper
* nodes are reached hierarchically as `v(x2.n1)`..`v(x2.n5)`.
*
* IN_DRV is worth probing here specifically: it is the level shifter's
* drive-rail-referenced output AND the thick-oxide gate of the output
* stage's first taper inverter (x2.XMP1/x2.XMN1), so spec Sec.2.3's
* thick-oxide gate ceiling applies to it -- but NEITHER per-cell campaign
* observes it under real drive. sim/output-stage-drive/ drives IN_DRV from
* an ideal 1 ns-edge source, and sim/level-shifter-oxide-safety/ terminates
* the level shifter's OUT in a lumped capacitor with no output-stage
* devices attached. Only this end-to-end chain has the level shifter's
* actual output buffer (XMPBUF2/XMNBUF2) driving the actual first-stage
* gate load. PR #116 already observed ~100 mV of overshoot on this node at
* a single 5 V smoke corner; this campaign quantifies it across the whole
* PVT grid, including the 6 V stretch rail where spec Sec.2.3's 6.0 V
* ceiling has the least margin. x2.n1..x2.n5 are carried alongside for the
* same reason -- decision record 0005 quantified their excursion under
* sim/output-stage-drive's ideal input edge, not under this real one.

vsup_logic VDD_LOGIC 0        dc {vlogic_val}
vsup_drv   VDD_DRV   0        dc {vdrv_val}
vgnd_logic GND_LOGIC 0        dc 0
rgndtie    GND_LOGIC GND_DRV  1m

vin IN GND_LOGIC pulse(0 {vlogic_val} 20n 1n 1n 300n 700n)

* 1 nF reference load (spec Sec.3), measured through a 0V ammeter so the
* load current (source = positive, sink = negative) is directly probeable
* as i(vimeas) without relying on a simulator-specific capacitor-current
* accessor -- matches sim/output-stage-drive/testbench/output_stage_tb.spice's
* convention, referenced here to GND_DRV (the drive-rail domain's own
* return) rather than the global node 0, since GND_DRV is only tied to 0
* through rgndtie/vgnd_logic in this fragment, not identical to it.
vimeas OUT outcap
cload outcap GND_DRV 1n

* ---------------------------------------------------------------
* DUT netlist included by this testbench (schematic)
* source     : design/netlist/gate_driver_core.spice
* sha256     : bf863872ac4ba5fcca2ae114f1ed338c4ce1161f278174e3dc27b8ab32d9d1ba
* ---------------------------------------------------------------

* gate_driver_core.spice -- xschem-generated hierarchical netlist fragment
* Source: design/gate_driver_core.sch (issue #98), which instantiates
* design/level_shifter.sch (x1) and design/output_stage.sch (x2) as
* sub-cells. Regenerate with (from the repo root, after `source sim/env.sh`):
*   xschem --rcfile design/xschemrc -x -q -n -s -o design/netlist \
*     design/gate_driver_core.sch
*   grep -v -e '^\*\* sch_path:' -e '^\*\* sym_path:' -e '^\.end$' \
*     design/netlist/gate_driver_core.spice > tmp && mv tmp design/netlist/gate_driver_core.spice
*   (then re-add this header block)
* The two greps drop the machine/worktree-local paths xschem prepends
* (design/README.md); a hierarchical netlist carries a `sym_path` line per
* expanded child symbol in addition to the top cell's `sch_path` line.
* This is a netlist FRAGMENT: devices and subcircuit definitions only, no
* .include/.lib/.temp/.control/.end (design/README.md) -- a testbench
* supplies models, corners, temp and sources.
*
* Block ports (spec/decision-records/0001, Decision 1 port list). The
* .subckt port ORDER below comes from design/gate_driver_core.sym's pin
* order, not from the decision record's table order -- connect by name:
*   VDD_LOGIC  -- 3.3V logic supply
*   GND_LOGIC  -- 3.3V logic return
*   IN         -- 3.3V logic input, non-inverting (decision record 0001,
*                 Decision 3): IN high -> OUT drives the external switch on
*   OUT        -- gate-drive output into the 1nF reference load (spec Sec.3)
*   VDD_DRV    -- 5V nominal / 6V stretch drive rail (spec Sec.3)
*   GND_DRV    -- drive-rail return
* GND_LOGIC and GND_DRV are two pins but one electrical reference node by
* design intent (decision record 0001, Decision 1) -- tie them together in
* any testbench that instantiates this fragment.
*
* Internal net IN_DRV is the level shifter's drive-rail-referenced logic
* output feeding the output stage's IN_DRV port. It is the only signal
* connection between the two sub-cells; VDD_DRV/GND_DRV are shared, and
* VDD_LOGIC/GND_LOGIC/IN reach the level shifter only.
*
* NOT present: UVLO (spec Sec.5, decision record 0001 Decisions 4-5) is in
* scope for this increment but has no implemented sub-cell yet, so this top
* cell is the level-shifter + output-stage signal path only.
**.subckt gate_driver_core VDD_LOGIC GND_LOGIC IN OUT VDD_DRV GND_DRV
*.ipin VDD_LOGIC
*.ipin GND_LOGIC
*.ipin IN
*.ipin VDD_DRV
*.ipin GND_DRV
*.opin OUT
x1 IN VDD_LOGIC GND_LOGIC VDD_DRV GND_DRV IN_DRV level_shifter
x2 VDD_DRV IN_DRV OUT GND_DRV output_stage
**.ends

* expanding   symbol:  level_shifter.sym # of pins=6
.subckt level_shifter in vdd_logic gnd_logic vdd_drv gnd_drv out

*.ipin in
*.ipin vdd_logic
*.ipin gnd_logic
*.ipin vdd_drv
*.ipin gnd_drv
*.opin out
XMNINV inb in gnd_logic gnd_logic nfet_03v3 L=0.28u W=5u nf=1 ad='int((nf+1)/2) * W/nf * 0.18u' as='int((nf+2)/2) * W/nf * 0.18u' pd='2*int((nf+1)/2) * (W/nf + 0.18u)'
+ ps='2*int((nf+2)/2) * (W/nf + 0.18u)' nrd='0.18u / W' nrs='0.18u / W' sa=0 sb=0 sd=0 m=1
XMPINV inb in vdd_logic vdd_logic pfet_03v3 L=0.28u W=10u nf=1 ad='int((nf+1)/2) * W/nf * 0.18u' as='int((nf+2)/2) * W/nf * 0.18u'
+ pd='2*int((nf+1)/2) * (W/nf + 0.18u)' ps='2*int((nf+2)/2) * (W/nf + 0.18u)' nrd='0.18u / W' nrs='0.18u / W' sa=0 sb=0 sd=0 m=1
XMNPDA na in gnd_logic gnd_logic nfet_03v3 L=0.28u W=20u nf=1 ad='int((nf+1)/2) * W/nf * 0.18u' as='int((nf+2)/2) * W/nf * 0.18u' pd='2*int((nf+1)/2) * (W/nf + 0.18u)'
+ ps='2*int((nf+2)/2) * (W/nf + 0.18u)' nrd='0.18u / W' nrs='0.18u / W' sa=0 sb=0 sd=0 m=1
XMNPDB nb inb gnd_logic gnd_logic nfet_03v3 L=0.28u W=20u nf=1 ad='int((nf+1)/2) * W/nf * 0.18u' as='int((nf+2)/2) * W/nf * 0.18u'
+ pd='2*int((nf+1)/2) * (W/nf + 0.18u)' ps='2*int((nf+2)/2) * (W/nf + 0.18u)' nrd='0.18u / W' nrs='0.18u / W' sa=0 sb=0 sd=0 m=1
XMNCASA nca vdd_logic na gnd_drv nfet_06v0 L=0.7u W=20u nf=1 ad='int((nf+1)/2) * W/nf * 0.18u' as='int((nf+2)/2) * W/nf * 0.18u' pd='2*int((nf+1)/2) * (W/nf + 0.18u)'
+ ps='2*int((nf+2)/2) * (W/nf + 0.18u)' nrd='0.18u / W' nrs='0.18u / W' sa=0 sb=0 sd=0 m=1
XMNCASB ncb vdd_logic nb gnd_drv nfet_06v0 L=0.7u W=20u nf=1 ad='int((nf+1)/2) * W/nf * 0.18u' as='int((nf+2)/2) * W/nf * 0.18u' pd='2*int((nf+1)/2) * (W/nf + 0.18u)'
+ ps='2*int((nf+2)/2) * (W/nf + 0.18u)' nrd='0.18u / W' nrs='0.18u / W' sa=0 sb=0 sd=0 m=1
XMPLATA nca ncb vdd_drv vdd_drv pfet_06v0 L=0.55u W=3u nf=1 ad='int((nf+1)/2) * W/nf * 0.18u' as='int((nf+2)/2) * W/nf * 0.18u' pd='2*int((nf+1)/2) * (W/nf + 0.18u)'
+ ps='2*int((nf+2)/2) * (W/nf + 0.18u)' nrd='0.18u / W' nrs='0.18u / W' sa=0 sb=0 sd=0 m=1
XMPLATB ncb nca vdd_drv vdd_drv pfet_06v0 L=0.55u W=3u nf=1 ad='int((nf+1)/2) * W/nf * 0.18u' as='int((nf+2)/2) * W/nf * 0.18u' pd='2*int((nf+1)/2) * (W/nf + 0.18u)'
+ ps='2*int((nf+2)/2) * (W/nf + 0.18u)' nrd='0.18u / W' nrs='0.18u / W' sa=0 sb=0 sd=0 m=1
XMPBUF1 nbuf1 ncb vdd_drv vdd_drv pfet_06v0 L=0.55u W=5u nf=1 ad='int((nf+1)/2) * W/nf * 0.18u' as='int((nf+2)/2) * W/nf * 0.18u' pd='2*int((nf+1)/2) * (W/nf + 0.18u)'
+ ps='2*int((nf+2)/2) * (W/nf + 0.18u)' nrd='0.18u / W' nrs='0.18u / W' sa=0 sb=0 sd=0 m=1
XMNBUF1 nbuf1 ncb gnd_drv gnd_drv nfet_06v0 L=0.7u W=5u nf=1 ad='int((nf+1)/2) * W/nf * 0.18u' as='int((nf+2)/2) * W/nf * 0.18u' pd='2*int((nf+1)/2) * (W/nf + 0.18u)'
+ ps='2*int((nf+2)/2) * (W/nf + 0.18u)' nrd='0.18u / W' nrs='0.18u / W' sa=0 sb=0 sd=0 m=1
XMPBUF2 out nbuf1 vdd_drv vdd_drv pfet_06v0 L=0.55u W=15u nf=1 ad='int((nf+1)/2) * W/nf * 0.18u' as='int((nf+2)/2) * W/nf * 0.18u'
+ pd='2*int((nf+1)/2) * (W/nf + 0.18u)' ps='2*int((nf+2)/2) * (W/nf + 0.18u)' nrd='0.18u / W' nrs='0.18u / W' sa=0 sb=0 sd=0 m=1
XMNBUF2 out nbuf1 gnd_drv gnd_drv nfet_06v0 L=0.7u W=15u nf=1 ad='int((nf+1)/2) * W/nf * 0.18u' as='int((nf+2)/2) * W/nf * 0.18u' pd='2*int((nf+1)/2) * (W/nf + 0.18u)'
+ ps='2*int((nf+2)/2) * (W/nf + 0.18u)' nrd='0.18u / W' nrs='0.18u / W' sa=0 sb=0 sd=0 m=1
.ends

* expanding   symbol:  output_stage.sym # of pins=4
.subckt output_stage VDD_DRV IN_DRV OUT GND_DRV
*.ipin IN_DRV
*.ipin VDD_DRV
*.ipin GND_DRV
*.opin OUT
XMP1 n1 IN_DRV VDD_DRV VDD_DRV pfet_06v0 L=0.55u W=4.4u nf=1 ad='int((nf+1)/2) * W/nf * 0.18u' as='int((nf+2)/2) * W/nf * 0.18u' pd='2*int((nf+1)/2) * (W/nf + 0.18u)'
+ ps='2*int((nf+2)/2) * (W/nf + 0.18u)' nrd='0.18u / W' nrs='0.18u / W' sa=0 sb=0 sd=0 m=1
XMN1 n1 IN_DRV GND_DRV GND_DRV nfet_06v0 L=0.70u W=2.0u nf=1 ad='int((nf+1)/2) * W/nf * 0.18u' as='int((nf+2)/2) * W/nf * 0.18u' pd='2*int((nf+1)/2) * (W/nf + 0.18u)'
+ ps='2*int((nf+2)/2) * (W/nf + 0.18u)' nrd='0.18u / W' nrs='0.18u / W' sa=0 sb=0 sd=0 m=1
XMP2 n2 n1 VDD_DRV VDD_DRV pfet_06v0 L=0.55u W=18.0u nf=1 ad='int((nf+1)/2) * W/nf * 0.18u' as='int((nf+2)/2) * W/nf * 0.18u' pd='2*int((nf+1)/2) * (W/nf + 0.18u)'
+ ps='2*int((nf+2)/2) * (W/nf + 0.18u)' nrd='0.18u / W' nrs='0.18u / W' sa=0 sb=0 sd=0 m=1
XMN2 n2 n1 GND_DRV GND_DRV nfet_06v0 L=0.70u W=8.0u nf=1 ad='int((nf+1)/2) * W/nf * 0.18u' as='int((nf+2)/2) * W/nf * 0.18u' pd='2*int((nf+1)/2) * (W/nf + 0.18u)'
+ ps='2*int((nf+2)/2) * (W/nf + 0.18u)' nrd='0.18u / W' nrs='0.18u / W' sa=0 sb=0 sd=0 m=1
XMP3 n3 n2 VDD_DRV VDD_DRV pfet_06v0 L=0.55u W=73.0u nf=1 ad='int((nf+1)/2) * W/nf * 0.18u' as='int((nf+2)/2) * W/nf * 0.18u' pd='2*int((nf+1)/2) * (W/nf + 0.18u)'
+ ps='2*int((nf+2)/2) * (W/nf + 0.18u)' nrd='0.18u / W' nrs='0.18u / W' sa=0 sb=0 sd=0 m=1
XMN3 n3 n2 GND_DRV GND_DRV nfet_06v0 L=0.70u W=33.0u nf=1 ad='int((nf+1)/2) * W/nf * 0.18u' as='int((nf+2)/2) * W/nf * 0.18u' pd='2*int((nf+1)/2) * (W/nf + 0.18u)'
+ ps='2*int((nf+2)/2) * (W/nf + 0.18u)' nrd='0.18u / W' nrs='0.18u / W' sa=0 sb=0 sd=0 m=1
XMP4 n4 n3 VDD_DRV VDD_DRV pfet_06v0 L=0.55u W=10.0u nf=1 ad='int((nf+1)/2) * W/nf * 0.18u' as='int((nf+2)/2) * W/nf * 0.18u' pd='2*int((nf+1)/2) * (W/nf + 0.18u)'
+ ps='2*int((nf+2)/2) * (W/nf + 0.18u)' nrd='0.18u / W' nrs='0.18u / W' sa=0 sb=0 sd=0 m=30
XMN4 n4 n3 GND_DRV GND_DRV nfet_06v0 L=0.70u W=10.0u nf=1 ad='int((nf+1)/2) * W/nf * 0.18u' as='int((nf+2)/2) * W/nf * 0.18u' pd='2*int((nf+1)/2) * (W/nf + 0.18u)'
+ ps='2*int((nf+2)/2) * (W/nf + 0.18u)' nrd='0.18u / W' nrs='0.18u / W' sa=0 sb=0 sd=0 m=14
XMP5 n5 n4 VDD_DRV VDD_DRV pfet_06v0 L=0.55u W=10.0u nf=1 ad='int((nf+1)/2) * W/nf * 0.18u' as='int((nf+2)/2) * W/nf * 0.18u' pd='2*int((nf+1)/2) * (W/nf + 0.18u)'
+ ps='2*int((nf+2)/2) * (W/nf + 0.18u)' nrd='0.18u / W' nrs='0.18u / W' sa=0 sb=0 sd=0 m=122
XMN5 n5 n4 GND_DRV GND_DRV nfet_06v0 L=0.70u W=10.0u nf=1 ad='int((nf+1)/2) * W/nf * 0.18u' as='int((nf+2)/2) * W/nf * 0.18u' pd='2*int((nf+1)/2) * (W/nf + 0.18u)'
+ ps='2*int((nf+2)/2) * (W/nf + 0.18u)' nrd='0.18u / W' nrs='0.18u / W' sa=0 sb=0 sd=0 m=55
XMP6 OUT n5 VDD_DRV VDD_DRV pfet_06v0 L=0.55u W=10.0u nf=1 ad='int((nf+1)/2) * W/nf * 0.18u' as='int((nf+2)/2) * W/nf * 0.18u' pd='2*int((nf+1)/2) * (W/nf + 0.18u)'
+ ps='2*int((nf+2)/2) * (W/nf + 0.18u)' nrd='0.18u / W' nrs='0.18u / W' sa=0 sb=0 sd=0 m=500
XMN6 OUT n5 GND_DRV GND_DRV nfet_06v0 L=0.70u W=10.0u nf=1 ad='int((nf+1)/2) * W/nf * 0.18u' as='int((nf+2)/2) * W/nf * 0.18u' pd='2*int((nf+1)/2) * (W/nf + 0.18u)'
+ ps='2*int((nf+2)/2) * (W/nf + 0.18u)' nrd='0.18u / W' nrs='0.18u / W' sa=0 sb=0 sd=0 m=220
.ends
