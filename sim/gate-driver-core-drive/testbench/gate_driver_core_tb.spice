* gate-driver-core-drive -- END-TO-END stimulus + reference load for
* design/netlist/gate_driver_core.spice (issue #98's combined top-level
* netlist: design/gate_driver_core.sch instantiating x1=level_shifter,
* x2=output_stage), substantiating spec/gate-driver.md Sec.3's block-level
* drive targets against the FULL signal chain -- logic-in (IN) ->
* level_shifter -> output_stage -> 1 nF reference load -- not an isolated
* sub-cell in isolation (issue #100; the two prior per-cell PVT campaigns,
* sim/output-stage-drive/ and sim/level-shifter-oxide-safety/, each only
* cover one half of this path).
*
* Netlist FRAGMENT. The harness supplies the title, .include of the
* gf180mcu models, the corner .lib sections, .temp, this experiment's DUT
* fragment (design/netlist/gate_driver_core.spice, .include'd ahead of this
* file -- see tb.json's "dut" key), the .control block and .end.
*
* This testbench uses this repo's default two rails (vlogic 3.3V logic
* supply, vdrv 5V/6V drive rail -- tb.json omits "rails" to get
* corners.DEFAULT_RAILS), matching the block's two actual supply domains
* (design/gate_driver_core.sch's VDD_LOGIC/GND_LOGIC and VDD_DRV/GND_DRV
* pins). The harness hands this fragment, per sim/harness/README.md:
*   vlogic_val / vlogic_nom   this PVT point's VDD_LOGIC supply / 3.30V nominal
*   vdrv_val   / vdrv_nom     this PVT point's VDD_DRV supply (nominal, +-tol,
*                             or the 6V stretch point) / 5.00V nominal
*   temp_c                    temperature for this PVT point (also applied
*                             via .temp)
*
* GND_LOGIC and GND_DRV are two pins but one electrical reference node by
* design intent (decision record 0001, Decision 1: "tied together with
* minimal impedance close to the device (star point)") -- modeled here as
* a milliohm-scale tie, matching
* sim/level-shifter-oxide-safety/testbench/level_shifter_tb.spice's
* convention, not a literal short.
*
* IN is driven at the block's actual 3.3V logic input pin (not an
* already-level-shifted IN_DRV the way sim/output-stage-drive/ drives its
* isolated DUT) -- an idealized rail-to-rail pulse referenced to
* GND_LOGIC, swinging the full vlogic_val rail (0 -> vlogic_val). Starts
* low so the whole chain settles to a well-defined DC operating point
* (OUT low, level shifter + output stage both non-inverting, decision
* record 0001 Decision 3) before the first transient edge. The pulse
* width/period is generous (300 ns high, 700 ns period) relative to the
* individual per-cell records' own worst-case delays (level shifter
* t_plh/t_phl <= ~1.2 ns, sim/level-shifter-oxide-safety; output stage
* tpdlh/tpdhl <= ~8.4 ns nominal / ~5.0 ns stretch,
* sim/output-stage-drive) so the combined end-to-end edge is fully settled
* long before the next transition, at every PVT point including the
* worst-case slow corners.

* Internal-node probing (tb.json's "measure" map). Because the DUT's top
* cell is a FRAGMENT whose own `.subckt gate_driver_core` line is commented
* out (design/netlist/gate_driver_core.spice), x1/x2 are instantiated at
* this deck's top level -- so the inter-cell net IN_DRV is a plain
* top-level node, `v(IN_DRV)`, while the output stage's internal taper
* nodes are reached hierarchically as `v(x2.n1)`..`v(x2.n5)`.
*
* IN_DRV is worth probing here specifically: it is the level shifter's
* drive-rail-referenced output AND the thick-oxide gate of the output
* stage's first taper inverter (x2.XMP1/x2.XMN1), so spec Sec.2.3's
* thick-oxide gate ceiling applies to it -- but NEITHER per-cell campaign
* observes it under real drive. sim/output-stage-drive/ drives IN_DRV from
* an ideal 1 ns-edge source, and sim/level-shifter-oxide-safety/ terminates
* the level shifter's OUT in a lumped capacitor with no output-stage
* devices attached. Only this end-to-end chain has the level shifter's
* actual output buffer (XMPBUF2/XMNBUF2) driving the actual first-stage
* gate load. PR #116 already observed ~100 mV of overshoot on this node at
* a single 5 V smoke corner; this campaign quantifies it across the whole
* PVT grid, including the 6 V stretch rail where spec Sec.2.3's 6.0 V
* ceiling has the least margin. x2.n1..x2.n5 are carried alongside for the
* same reason -- decision record 0005 quantified their excursion under
* sim/output-stage-drive's ideal input edge, not under this real one.

vsup_logic VDD_LOGIC 0        dc {vlogic_val}
vsup_drv   VDD_DRV   0        dc {vdrv_val}
vgnd_logic GND_LOGIC 0        dc 0
rgndtie    GND_LOGIC GND_DRV  1m

vin IN GND_LOGIC pulse(0 {vlogic_val} 20n 1n 1n 300n 700n)

* 1 nF reference load (spec Sec.3), measured through a 0V ammeter so the
* load current (source = positive, sink = negative) is directly probeable
* as i(vimeas) without relying on a simulator-specific capacitor-current
* accessor -- matches sim/output-stage-drive/testbench/output_stage_tb.spice's
* convention, referenced here to GND_DRV (the drive-rail domain's own
* return) rather than the global node 0, since GND_DRV is only tied to 0
* through rgndtie/vgnd_logic in this fragment, not identical to it.
vimeas OUT outcap
cload outcap GND_DRV 1n
