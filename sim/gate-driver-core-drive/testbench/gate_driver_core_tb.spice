* gate-driver-core-drive -- END-TO-END stimulus + reference load for
* design/netlist/gate_driver_core.spice (issue #98's combined top-level
* netlist: design/gate_driver_core.sch instantiating x1=level_shifter,
* x2=output_stage), substantiating spec/gate-driver.md Sec.3's block-level
* drive targets against the FULL signal chain -- logic-in (IN) ->
* level_shifter -> output_stage -> 1 nF reference load -- not an isolated
* sub-cell in isolation (issue #100; the two prior per-cell PVT campaigns,
* sim/output-stage-drive/ and sim/level-shifter-oxide-safety/, each only
* cover one half of this path).
*
* Netlist FRAGMENT. The harness supplies the title, .include of the
* gf180mcu models, the corner .lib sections, .temp, this experiment's DUT
* fragment (design/netlist/gate_driver_core.spice, .include'd ahead of this
* file -- see tb.json's "dut" key), the .control block and .end.
*
* This testbench uses this repo's default two rails (vlogic 3.3V logic
* supply, vdrv 5V/6V drive rail -- tb.json omits "rails" to get
* corners.DEFAULT_RAILS), matching the block's two actual supply domains
* (design/gate_driver_core.sch's VDD_LOGIC/GND_LOGIC and VDD_DRV/GND_DRV
* pins). The harness hands this fragment, per sim/harness/README.md:
*   vlogic_val / vlogic_nom   this PVT point's VDD_LOGIC supply / 3.30V nominal
*   vdrv_val   / vdrv_nom     this PVT point's VDD_DRV supply (nominal, +-tol,
*                             or the 6V stretch point) / 5.00V nominal
*   temp_c                    temperature for this PVT point (also applied
*                             via .temp)
*
* GND_LOGIC and GND_DRV are two pins but one electrical reference node by
* design intent (decision record 0001, Decision 1: "tied together with
* minimal impedance close to the device (star point)") -- modeled here as
* a milliohm-scale tie, matching
* sim/level-shifter-oxide-safety/testbench/level_shifter_tb.spice's
* convention, not a literal short.
*
* IN is driven at the block's actual 3.3V logic input pin (not an
* already-level-shifted IN_DRV the way sim/output-stage-drive/ drives its
* isolated DUT) -- an idealized rail-to-rail pulse referenced to
* GND_LOGIC, swinging the full vlogic_val rail (0 -> vlogic_val). Starts
* low so the whole chain settles to a well-defined DC operating point
* (OUT low, level shifter + output stage both non-inverting, decision
* record 0001 Decision 3) before the first transient edge. The pulse
* width/period is generous (300 ns high, 700 ns period) relative to the
* individual per-cell records' own worst-case delays (level shifter
* t_plh/t_phl <= ~1.2 ns, sim/level-shifter-oxide-safety; output stage
* tpdlh/tpdhl <= ~8.4 ns nominal / ~5.0 ns stretch,
* sim/output-stage-drive) so the combined end-to-end edge is fully settled
* long before the next transition, at every PVT point including the
* worst-case slow corners.

vsup_logic VDD_LOGIC 0        dc {vlogic_val}
vsup_drv   VDD_DRV   0        dc {vdrv_val}
vgnd_logic GND_LOGIC 0        dc 0
rgndtie    GND_LOGIC GND_DRV  1m

vin IN GND_LOGIC pulse(0 {vlogic_val} 20n 1n 1n 300n 700n)

* 1 nF reference load (spec Sec.3), measured through a 0V ammeter so the
* load current (source = positive, sink = negative) is directly probeable
* as i(vimeas) without relying on a simulator-specific capacitor-current
* accessor -- matches sim/output-stage-drive/testbench/output_stage_tb.spice's
* convention, referenced here to GND_DRV (the drive-rail domain's own
* return) rather than the global node 0, since GND_DRV is only tied to 0
* through rgndtie/vgnd_logic in this fragment, not identical to it.
vimeas OUT outcap
cload outcap GND_DRV 1n
