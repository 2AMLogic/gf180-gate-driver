* uvlo-trip-verification -- `klt sim` circuit BODY for the UVLO trip-voltage rows
* (T1 item 5, issue #377).
*
* Same DUT, boundary condition and stimulus as ../run_uvlo_trip.py's hysteresis
* deck (the harness behind records/20260826-013053-6299c36.md): the flat
* fragment design/netlist/uvlo.spice, VDD_DRV driven by a 0 -> 6 V -> 0 V
* triangle (20 us per edge; quasi-static for the bistable comparator, which is
* why this is a transient ramp and not a .dc sweep -- see run_uvlo_trip.py's
* docstring), a weak 100k pull-up plus 6 fF on OUT. No models/.lib/.temp/
* .control/.end -- klt owns those. VDD_DRV is the quantity under test, so this
* request carries no corners.supply_v axis.
*
* Trip points are the VDD_DRV values at which the internal `lockout` node
* crosses 1.5 V (the harness's fixed absolute level: below every measured
* corner's trip voltage, above 0 V).
*
* Carried here, not in options.ngspice_options: the batch fleet's runner drops
* that request field (see ../../gate-driver-core-drive-with-uvlo/klt/body.spice).
.options reltol=1e-4

.include "design.ngspice"
.include "../../../design/netlist/uvlo.spice"

vsup VDD_DRV 0 pwl(0 0 20u 6 40u 0)
vgnd GND_DRV 0 dc 0
rpu VDD_DRV OUT 100k
cload OUT GND_DRV 6f
